Experimental steady-supply K7222 native capture; unqualified hypothesis
.param yoke_horizontal_r=2
.param yoke_horizontal_l=0.00400691178088492
.param tube_anode_c=1e-09
.param tube_hv_leakage=200000000
.param l4_coupling=0
.param isolated_cap_leakage=1000000000
.param driver_low=0.15
.param driver_high=4.2
.param driver_r_low=8
.param driver_r_high=35
.param driver_tau=4e-09
.param gate_threshold=1.4
.param gate_span=0.08
.param gate_tau=5e-09
.param gate_input_c=4e-12
.param cable_r=0.3
.param cable_c=1.5e-10
.param return_r=0.2
.param contrast_trim=1100
.param contrast_r=10000
.param contrast_position=0.5
.param vertical_load=100000
.param sync_load=100000
.param horizontal_trim_fraction=0.3775
.param horizontal_tank_l=0.00145
.param horizontal_tank_r=1
.param horizontal_coupling=0.995
.param horizontal_driver_l=0.005
.param horizontal_driver_r=2
.param horizontal_driver_ratio=3
.param horizontal_secondary_r=0.3
.param horizontal_choke_r=0.5
.param horizontal_choke_l=0.0001
.param horizontal_linearity_r=0.1
.param horizontal_linearity_l=2e-05
.param horizontal_compensation_r=0.1
.param horizontal_compensation_l=5e-06
.param horizontal_brightness_fraction=0.5
.param horizontal_focus_fraction=0.5
.param vertical_trim=22000
.param vertical_bf=60
.param sync_enabled=1
.param sync_period=0.0208
.param sync_loss_start=0.3
.param sync_loss_end=0.4
.param height_trim=11000
.param vertical_compensation=1e-10
.param retrace_bf=100
.param symmetry_fraction=0.5
.param linearity_lower=23500
.param linearity_upper=23500
.param yoke_vertical_r=10
.param yoke_vertical_l=0.0199867713595455
.param output_bf=60
.param reg5_position=0.5
.param reg5_bf=60
.param reg5_input=12
.param neck_c2=1e-07
.param q_is=1e-14
.param q_bf=60
.param q_vaf=60
.param q_tf=2e-09
.param q_tr=1e-08
.param q_cje=2e-11
.param q_cjc=8e-12
.param d_is=1e-09
.param d_n=1.5
.param d_rs=1
.param d_cjo=3e-12
.param d_tt=4e-09
.param tube_cathode_c=2e-11
C201 intensity_gate base_i 1e-10
C202 sync_gate sync_base 1e-10
D201 0 rx_video 1AD50_BOUND
D202 0 rx_bsyn 1AD50_BOUND
D203 0 rx_intens 1AD50_BOUND
D204 clamp_i base_i 1AD50_BOUND
D205 clamp_i collector_i 1AD50_BOUND
D206 0 reference9 Z9_BOUND
Q201 collector_i base_i 0 SSY20A_BOUND
Q202 p12 collector_i contrast_low SSY20A_BOUND
Q203 sync_c sync_base 0 SSY20A_BOUND
R201 0 rx_video 160.0
R202 rx_video p5 270.0
R203 0 rx_bsyn 160.0
R204 rx_bsyn p5 270.0
R205 0 rx_intens 160.0
R206 rx_intens p5 270.0
R207 p5 vid 330.0
R208 p5 intensity_gate 330.0
R209 intensity_gate clamp_i 390.0
R210 p12 collector_i 2700.0
R211 contrast_adjust collector_i 2700.0
R212 reference9 contrast_adjust {contrast_trim}
R213 contrast_low 0 5100.0
R214 sync_gate sync_base 1000.0
R215 p12 sync_feed 390.0
R216 sync_feed sync_c 390.0
X201 rx_video rx_video video_inv rx_bsyn rx_bsyn sync_gate 0 intensity_gate rx_intens rx_intens vid video_inv video_inv p5 T200_BOUND
C301 vf1 0 2.2e-09
C302 vf1 vf2 1e-08
C306 vertical_trigger 0 1e-09
D305 vertical_trigger vf_diode 1AD50_BOUND
R300 sync_gate vf1 15000.0
R303 vf2 0 82000.0
R304 vf2 vf_diode 1500.0
C401 vertical_supply 0 4.7e-05
C408 vertical_timing vertical_base 2.2e-07
Q409 vertical_timing vertical_trigger vertical_emitter VERTICAL_NPN_BOUND
Q410 vertical_pulse vertical_base 0 VERTICAL_NPN_BOUND
R400 p12 vertical_supply 130.0
R402 vertical_supply vertical_timing 470.0
R403 vertical_supply vertical_pulse 1000.0
R404 vertical_pulse vertical_trigger 33000.0
R405 vertical_emitter 0 470.0
R406 vertical_emitter vertical_trim {vertical_trim}
R407 vertical_trim vertical_base 100000.0
C602 ramp_inv vertical_ramp 220n
C603 ramp_inv ramp_comp {vertical_compensation}
C610 ramp_bias 0 100u
D604 ramp_noninv vertical_pulse VERTICAL_DIODE
D611 ramp_raw ramp_diode VERTICAL_DIODE
D612 ramp_diode vertical_ramp VERTICAL_DIODE
Q606 ramp_inv retrace_base ramp_bias VERTICAL_PNP_BOUND
R600 ramp_inv height_trim 75k
R601 height_trim 0 {height_trim}
R605 ramp_noninv retrace_base 4.7k
R607 ramp_noninv ramp_bias 10k
R608 vertical_reference ramp_bias 1.8k
R609 ramp_bias 0 750
R613 vertical_ramp ramp_limit 160
R614 ramp_limit 0 33
X615 0 ramp_inv ramp_noninv vertical_reference 0 ramp_raw p12 p12 ramp_comp ramp_limit MAA723_BOUND
C703 amp_vp 0 22u
C704 p22 0 100u
C705 0 n16 47u
C706 vertical_reference 0 2.2u
C707 symmetry 0 2.2u
C714 amp_co amp_out 18p
C715 amp_cb comp_series 220p
D701 zener_join amp_vp VERT_Z16
D702 zener_join 0 VERTICAL_DIODE
D720 upper_base bias_diode VERTICAL_DIODE
D721 bias_diode bias_middle VERTICAL_DIODE
D722 bias_middle lower_base VERTICAL_DIODE
D735 threshold_lower threshold_upper VERTICAL_DIODE
D736 threshold_upper amp_inv VERTICAL_DIODE
D737 amp_inv threshold_upper VERTICAL_DIODE
Q723 p22 upper_base upper_emitter VERTICAL_NPN_BOUND
Q724 p22 upper_emitter y1 VERT_POWER_N
Q725 n16 lower_base lower_emitter VERTICAL_PNP_BOUND
Q726 n16 lower_emitter y1 VERT_POWER_P
R700 p22 amp_vp 750
R708 0 sym_top 910
R710 sym_bottom vertical_reference 10k
R711 symmetry amp_noninv 750
R712 vertical_ramp amp_inv 1.5k
R716 comp_series amp_ca 1.5k
R717 amp_out bias_middle 47
R718 p22 upper_base 7.5k
R719 lower_base n16 7.5k
R727 upper_emitter y1 160
R728 y1 lower_emitter 160
R729 y1 y2 430
R730 y2 0 3.9
R731 amp_inv y2 1.5k
R732 threshold_lower y2 5.6k
R733 threshold_upper y2 5.6k
R734 threshold_lower 0 12k
R738 lin_lower threshold_lower 22k
R739 vertical_reference lin_lower {linearity_lower}
R740 lin_upper threshold_upper 15k
R741 vertical_reference lin_upper {linearity_upper}
X709 sym_top symmetry sym_bottom VERT_POT
X713 amp_ca amp_inv amp_noninv n16 amp_co amp_out amp_vp amp_cb LM709_FAMILY
C505 reg5_base 0 2.2e-05
C506 p5 0 0.001
D503 0 reg5_zener REG5_ZENER
Q504 reg5_collector reg5_base p5 REG5_NPN
R500 p12 reg5_top 430.0
R502 p12 reg5_collector 47.0
X501 reg5_top reg5_base reg5_zener REG5_POT
C1001 h_supply 0 0.001
C1005 h_trim 0 0.0001
C1008 h_pd sync_c 6.8e-09
C1009 h_pd h_control 6.8e-10
C1011 h_control h_pdreturn 1e-08
C1012 h_pdreturn h_feedback 1e-07
C1013 h_control 0 2.2e-08
C1015 h_reactbase h_r19 3.3e-07
C1017 h_reactbase h_reactemit 4.7e-06
C1019 h_reactemit h_r21 1e-05
C1021 h_tank h_r21 1e-07
C1023 h_tank h_base 3.3e-08
C1025 h_col h_base 1e-09
C1028 h_drivetop h_drivecol 2.2e-07
C1030 h_snub h_drivecol 4.7e-08
D1032 h_trim h_pd HOR_D
D1033 h_control h_pd HOR_D
Q1034 h_tank h_reactbase h_reactemit HOR_N
Q1035 h_col h_base h_drivebase HOR_N
Q1036 h_drivecol h_drivebase 0 HOR_DRIVER_N
R1000 p12 h_supply 150.0
R1002 h_supply h_trimtop 5600.0
R1003 h_trimbottom h_therm 680.0
R1004 h_therm 0 470.0
R1006 h_trim h_pd 15000.0
R1007 h_pd h_control 15000.0
R1010 h_control h_pdreturn 3900.0
R1014 h_control h_reactbase 5600.0
R1016 h_r19 0 180.0
R1018 h_reactemit 0 330.0
R1020 h_r21 0 27.0
R1022 h_tankright h_col 120.0
R1024 h_col h_base 2200.0
R1026 h_drivebase 0 27.0
R1027 p22 h_drivetop 62.0
R1029 h_drivetop h_snub 180.0
X1031 h_trimtop h_trim h_trimbottom HORIZONTAL_TRIM
X1037 h_tank h_supply h_tankright HORIZONTAL_TANK
X1038 h_drivetop h_drivecol h_outputbase 0 HORIZONTAL_DRIVER
C1 p41 0 22u
C2 p41 0 {neck_c2}
C3 0 g1 680p
C4 vid base 150p
D1 clamp base 1AD50_BOUND
D2 clamp collector 1AD50_BOUND
D3 collector p41 1AD50_BOUND
D4 intens brightness 1AD50_BOUND
D5 collector brightness 1AD50_BOUND
D6 tail collector 1AD50_BOUND
Q1 collector base 0 SSY20A_BOUND
R1 ug1 g1 100k
R2 ug2 g2 2.2meg
R3 ug4 g4 100k
R4 brightness cathode 390
R5 brightness tail 470
R6 vid clamp 390
R7 p41 collector 390
R8 tail 0 1.5k
C1101 p5 0 4.7e-11
C1102 p12 0 4.7e-11
C1103 p12 0 2.2e-05
C1105 h_feed 0 0.00022
C1106 h_feed h_boosttap 4.7e-12
C1107 h_feed h_boost 0.00022
C1108 h_hot 0 1e-08
C1109 h_hot 0 1e-09
C1111 h_linout hy1 4.7e-07
C1112 hy2 h_return 1e-07
C1113 hy2 h_return 3.3e-07
C1115 h_hot h_rectmid 1.5e-10
C1116 h_rectmid h_g2raw 1.5e-10
C1120 h_divtop 0 1e-08
C1121 h_g1raw 0 1e-05
D1127 p35 p41 HOR_Z6
D1128 h_feed h_boosttap HOR_RECT
D1129 0 h_hot HOR_RECT
D1130 h_hot h_g2raw HOR_RECT
D1131 h_g1raw h_sync HOR_RECT
D1132 h_hvac eht HOR_HV_RECT
Q1133 h_hot h_outbase 0 HOR_OUTPUT_N
R1100 p12 p10_7 15.0
R1104 p41 h_chokein 6.8
R1110 h_hot h_linout 82.0
R1114 h_outbase 0 1800.0
R1117 h_g2raw h_divtop 2700.0
R1118 h_divtop ug2 150000.0
R1119 ug2 0 1000000.0
X1122 h_chokein h_feed HORIZONTAL_CHOKE
X1123 h_hot h_linout HORIZONTAL_LINEARITY
X1134 h_g1raw ug1 0 HORIZONTAL_BRIGHTNESS
X1135 h_divtop ug4 0 HORIZONTAL_FOCUS
X1136 h_hot h_boosttap h_lower13 h_feedback h_boost h_return 0 h_sync h_upper2 h_hvac h_hvcold h_upper2 t3_x1_3 t3_x1_5 h_hvcold t3_x1_9 t3_x1_12 h_lower13 t3_x1_10 h_boost T3_CANDIDATE
X101 logic_video tx_video computer_return S37_DRIVER
X102 logic_bsyn tx_bsyn computer_return S37_DRIVER
X103 logic_intens tx_intens computer_return S37_DRIVER
* 012-6921:L4:1 same-terminal-polarity hypothesis
RL4_1 h_outputbase l4_internal_1 {horizontal_compensation_r}
LL4_1 l4_internal_1 h_outbase {horizontal_compensation_l}
* 012-6921:L4:2 same-terminal-polarity hypothesis
RL4_2 h_outputbase l4_internal_2 {horizontal_compensation_r}
LL4_2 l4_internal_2 h_outbase {horizontal_compensation_l}
* 012-6921:L4:3 same-terminal-polarity hypothesis
RL4_3 h_outbase l4_internal_3 {horizontal_compensation_r}
LL4_3 l4_internal_3 h_outbase {horizontal_compensation_l}
* Bounded engineering families, NOT measured SC237E/SF1260/SF1280 curves.
.model HOR_D D(IS=1n N=1.5 RS=2 CJO=2p TT=5n)
.model HOR_N NPN(IS=1e-14 BF=100 VAF=80 CJE=20p CJC=8p TF=2n TR=10n)
.model HOR_DRIVER_N NPN(IS=1e-12 BF=60 VAF=80 CJE=150p CJC=80p TF=20n TR=100n)
.subckt HORIZONTAL_TRIM top wiper bottom
Ra top wiper {1000*(1-horizontal_trim_fraction)}
Rb wiper bottom {1000*horizontal_trim_fraction}
.ends HORIZONTAL_TRIM
* Tapped, phase-inverting tank. Inductance is PER HALF winding.
.subckt HORIZONTAL_TANK left middle right
Ra left a {horizontal_tank_r}
Rb right b {horizontal_tank_r}
La a middle {horizontal_tank_l}
Lb middle b {horizontal_tank_l}
Kcore La Lb {horizontal_coupling}
.ends HORIZONTAL_TANK
* Opposite polarity secondary for turn-off transformer drive.
.subckt HORIZONTAL_DRIVER top collector base ground
Rp top p {horizontal_driver_r}
Lp p collector {horizontal_driver_l}
Rs s base {horizontal_secondary_r}
Ls ground s {horizontal_driver_l/horizontal_driver_ratio^2}
Kcore Lp Ls {horizontal_coupling}
.ends HORIZONTAL_DRIVER
* Output families and normal-operation ancillary components; no SOA claim.
.model HOR_Z6 D(IS=1n N=1.5 RS=2 BV=6.2 IBV=1m)
.model HOR_RECT D(IS=10n N=1.5 RS=.2 CJO=20p TT=100n)
.model HOR_HV_RECT D(IS=1n N=2 RS=100 CJO=1p TT=100n)
.model HOR_OUTPUT_N NPN(IS=1e-10 BF=20 VAF=100 CJE=1n CJC=200p TF=100n TR=500n)
.subckt HORIZONTAL_CHOKE a b
Rloss a n {horizontal_choke_r}
Lcore n b {horizontal_choke_l}
.ends HORIZONTAL_CHOKE
.subckt HORIZONTAL_LINEARITY a b
Rloss a n {horizontal_linearity_r}
Lcore n b {horizontal_linearity_l}
.ends HORIZONTAL_LINEARITY
.subckt HORIZONTAL_COMPENSATION a b
Rloss a n {horizontal_compensation_r}
Lcore n b {horizontal_compensation_l}
.ends HORIZONTAL_COMPENSATION
.subckt HORIZONTAL_BRIGHTNESS low wiper high
Ra low wiper {1meg*horizontal_brightness_fraction}
Rb wiper high {1meg*(1-horizontal_brightness_fraction)}
.ends HORIZONTAL_BRIGHTNESS
.subckt HORIZONTAL_FOCUS high wiper low
Ra high wiper {1meg*(1-horizontal_focus_fraction)}
Rb wiper low {1meg*horizontal_focus_fraction}
.ends HORIZONTAL_FOCUS

* Generic devices; historical connectivity does not establish device accuracy.
.model VERTICAL_NPN_BOUND NPN(IS=1e-14 BF={vertical_bf} VAF=60 CJE=20p CJC=8p TF=2n TR=20n)
.model VERTICAL_DIODE D(IS=2n RS=2 N=1.7 CJO=2p TT=5n)
.model VERTICAL_PNP_BOUND PNP(IS=1e-14 BF={retrace_bf} VAF=60 CJE=30p CJC=10p TF=5n TR=50n)
* LM723-family functional equivalent: TI SNVS765C p2 metal-can pin contract.
* cs inv noninv ref vminus out collector vplus compensation current-limit
* NOT a transistor-level Tesla MAA723 model. No thermal/SOA qualification.
* Assumed gm 1 mS, gain 10000, +/-200 uA drive and 30 pF internal pole.
.subckt MAA723_BOUND cs inv noninv ref vm out vc vp comp cl
Breference ref_i vm V={min(7.15,max(v(vp,vm)-2.35,0))}
Rreference ref_i ref 10
Breference_draw vp vm I={max(i(Breference)*-1,0)}
Bquiescent vp vm I={1.7m*min(max(v(vp,vm)/9.5,0),1)}
Rinput inv noninv 10Meg
Bdrive_up vp comp I={max(min(.001*v(noninv,inv),200u),0)*min(max(v(vp,vm)/9.5,0),1)}
Bdrive_down comp vm I={max(min(-.001*v(noninv,inv),200u),0)*min(max(v(vp,vm)/9.5,0),1)}
Rgain comp vm 10Meg
Cinternal comp vm 30p
Dupper comp vp M723_CLAMP
Dlower vm comp M723_CLAMP
Qpass vc comp out M723_PASS
Qlimit comp cl cs M723_LIMIT
Rout out vm 1Meg
.model M723_PASS NPN(IS=1e-14 BF=100 VAF=60 CJE=30p CJC=10p TF=5n)
.model M723_LIMIT NPN(IS=1e-14 BF=100 VAF=60)
.model M723_CLAMP D(IS=1e-12 RS=10)
.ends MAA723_BOUND

* Provisional P09A substitute: LM709 manufacturer internal circuit.
* TI/National SNOS659A, PDF page 4 (printed 3), metal-can pin order.
* Port order: compensation A, inverting, noninverting, V-, output
* compensation, output, V+, compensation B. Board DIP pins: 3,4,5,6,9,10,11,12.
* Resistors/topology transcribed; transistor parameters are engineering
* assumptions, NOT characterized P09A/LM709 silicon. No SOA/thermal model.
.subckt LM709_FAMILY ca inv noninv vm co out vp cb
Q1 n1 noninv tail N709
Q2 ca inv tail N709
Q3 n3 n1 e3 N709
Q4 n3 e3 bias N709
Q5 cb ca e5 N709
Q6 cb e5 bias N709
Q7 vp n3 e7 N709
Q8 vp cb e8 N709
Q9 co bias n9e P709
Q10 tailbase tailbase vm N709
Q11 tail tailbase tail_e N709
Q12 c12 co e12 N709
Q13 vm c12 out P709
Q14 vp c12 out N709
Q15 bias_top bias_top bias N709
R1 e7 n1 25k
R2 e7 ca 25k
R3 e3 bias_top 3k
R4 e5 bias_top 3k
R5 vp n3 10k
R6 vp cb 10k
R7 e8 n9e 1k
R8 bias tap 3.6k
R9 n9e tap 10k
R10 tap tailbase 10k
R11 tail_e vm 2.4k
R12 co e12 10k
R13 e12 vm 75
R14 vp c12 20k
R15 n9e out 30k
.model N709 NPN(IS=1e-14 BF=100 VAF=100 CJE=4p CJC=2p TF=.2n TR=20n)
.model P709 PNP(IS=1e-14 BF=50 VAF=50 CJE=4p CJC=2p TF=20n TR=100n)
.ends LM709_FAMILY

* Engineering bounds, not fitted factory transistor curves.
.model VERT_Z16 D(IS=1n N=1.5 RS=2 BV=16 IBV=1m)
.model VERT_POWER_N NPN(IS=1e-12 BF={output_bf} VAF=80 CJE=200p CJC=80p TF=20n TR=200n)
.model VERT_POWER_P PNP(IS=1e-12 BF={output_bf} VAF=80 CJE=200p CJC=80p TF=20n TR=200n)
* Source R58 remains one inventoried device; no duplicate source identities.
.subckt VERT_POT top wiper bottom
Ra top wiper {470*symmetry_fraction}
Rb wiper bottom {470*(1-symmetry_fraction)}
.ends VERT_POT

* Generic bounded models; not specimen-calibrated SF1260/ZC5.1.
.model REG5_NPN NPN(IS=1e-14 BF={reg5_bf} VAF=60 CJE=40p CJC=15p TF=20n TR=100n)
.model REG5_ZENER D(IS=1n RS=5 N=1.5 BV=5.1 IBV=.005 CJO=100p)
.subckt REG5_POT top wiper bottom
Rtop top wiper {100*reg5_position}
Rbottom wiper bottom {100*(1-reg5_position)}
.ends REG5_POT

* BOUNDED GENERIC FAMILY MODELS: not manufacturer-calibrated SSY20A/1AD50.
* Every free parameter and its exploratory bounds is declared in the profile.
.model SSY20A_BOUND NPN(IS={q_is} BF={q_bf} VAF={q_vaf}
+ TF={q_tf} TR={q_tr} CJE={q_cje} CJC={q_cjc})
.model 1AD50_BOUND D(IS={d_is} N={d_n} RS={d_rs} CJO={d_cjo} TT={d_tt})

* Bounded functional models, NOT fitted 74S37/T200 device curves.
* Source E03 NAND logic is evaluated by the digital adapter upstream.
.subckt S37_DRIVER logic output ground params: resistance=1 slew=1
Btarget target ground V={driver_low+(driver_high-driver_low)*v(logic,ground)}
Redge target edge 1k
Cedge edge ground {driver_tau*slew/1000}
Boutput output ground I={(v(output,ground)-v(edge,ground))/(resistance*(driver_r_low+(driver_r_high-driver_r_low)*min(1,max(0,(v(edge,ground)-driver_low)/(driver_high-driver_low)))))}
.ends S37_DRIVER
* Input current is an explicit assumed TTL loading law; no implied logic input
* at 0.5 VCC. Threshold and transition span have independent bounded parameters.
.subckt GATE a b y ground supply
Ba a ground I={20u-220u/(1+exp((v(a,ground)-gate_threshold)/gate_span))}
Bb b ground I={20u-220u/(1+exp((v(b,ground)-gate_threshold)/gate_span))}
Ca a ground {gate_input_c}
Cb b ground {gate_input_c}
Btruth truth ground V={1-1/(1+exp(-(v(a,ground)-gate_threshold)/gate_span))/(1+exp(-(v(b,ground)-gate_threshold)/gate_span))}
Rdelay truth smooth 1k
Cdelay smooth ground {gate_tau/1000}
Boutput y ground I={(v(y,ground)-(.15+max(v(supply,ground)-.95,0)*v(smooth,ground)))/(10+70*v(smooth,ground))}
.ends GATE
.subckt T200_BOUND a1 b1 y1 a2 b2 y2 ground y3 a3 b3 y4 a4 b4 supply
Xg1 a1 b1 y1 ground supply GATE
Xg2 a2 b2 y2 ground supply GATE
Xg3 a3 b3 y3 ground supply GATE
Xg4 a4 b4 y4 ground supply GATE
.ends T200_BOUND
.model Z9_BOUND D(IS=1n N=1.5 RS=5 BV=9.1 IBV=1m CJO=30p)

.subckt T3_CANDIDATE_CORE w0p w0n w1p w1n w2p w2n w3p w3n w4p w4n w5p w5n w6p w6n w7p w7n w8p w8n w9p w9n w10p w10n w11p w11n w12p w12n w13p w13n w14p w14n
Rw0 w0p r0 0.2
Rskin0 r0 skin0 10
Lskin0 r0 skin0 1.8e-06
Ll0 skin0 l0 2e-07
Cw0 w0p w0n 1e-11
Rw1 w1p r1 0.2
Rskin1 r1 skin1 10
Lskin1 r1 skin1 1.8e-06
Ll1 skin1 l1 2e-07
Cw1 w1p w1n 1e-11
Rw2 w2p r2 0.2
Rskin2 r2 skin2 10
Lskin2 r2 skin2 1.8e-06
Ll2 skin2 l2 2e-07
Cw2 w2p w2n 1e-11
Rw3 w3p r3 0.2
Rskin3 r3 skin3 10
Lskin3 r3 skin3 1.8e-06
Ll3 skin3 l3 2e-07
Cw3 w3p w3n 1e-11
Rw4 w4p r4 0.2
Rskin4 r4 skin4 10
Lskin4 r4 skin4 1.8e-06
Ll4 skin4 l4 2e-07
Cw4 w4p w4n 1e-11
Rw5 w5p r5 0.2
Rskin5 r5 skin5 10
Lskin5 r5 skin5 1.8e-06
Ll5 skin5 l5 2e-07
Cw5 w5p w5n 1e-11
Rw6 w6p r6 0.2
Rskin6 r6 skin6 10
Lskin6 r6 skin6 1.8e-06
Ll6 skin6 l6 2e-07
Cw6 w6p w6n 1e-11
Rw7 w7p r7 1000
Rskin7 r7 skin7 5000
Lskin7 r7 skin7 0.0027
Ll7 skin7 l7 0.0003
Cw7 w7p w7n 1.5e-11
Rw8 w8p r8 0.2
Rskin8 r8 skin8 10
Lskin8 r8 skin8 1.8e-06
Ll8 skin8 l8 2e-07
Cw8 w8p w8n 1e-11
Rw9 w9p r9 0.2
Rskin9 r9 skin9 10
Lskin9 r9 skin9 1.8e-06
Ll9 skin9 l9 2e-07
Cw9 w9p w9n 1e-11
Rw10 w10p r10 0.2
Rskin10 r10 skin10 10
Lskin10 r10 skin10 1.8e-06
Ll10 skin10 l10 2e-07
Cw10 w10p w10n 1e-11
Rw11 w11p r11 0.2
Rskin11 r11 skin11 10
Lskin11 r11 skin11 1.8e-06
Ll11 skin11 l11 2e-07
Cw11 w11p w11n 1e-11
Rw12 w12p r12 0.2
Rskin12 r12 skin12 10
Lskin12 r12 skin12 1.8e-06
Ll12 skin12 l12 2e-07
Cw12 w12p w12n 1e-11
Rw13 w13p r13 0.2
Rskin13 r13 skin13 10
Lskin13 r13 skin13 1.8e-06
Ll13 skin13 l13 2e-07
Cw13 w13p w13n 1e-11
Rw14 w14p r14 0.2
Rskin14 r14 skin14 10
Lskin14 r14 skin14 1.8e-06
Ll14 skin14 l14 2e-07
Cw14 w14p w14n 1e-11
Ew1 l1 w1n l0 w0n 0.194444444444444
Fw1 l0 w0n Ew1 -0.194444444444444
Ew2 l2 w2n l0 w0n 0.194444444444444
Fw2 l0 w0n Ew2 -0.194444444444444
Ew3 l3 w3n l0 w0n 0.194444444444444
Fw3 l0 w0n Ew3 -0.194444444444444
Ew4 l4 w4n l0 w0n 0.194444444444444
Fw4 l0 w0n Ew4 -0.194444444444444
Ew5 l5 w5n l0 w0n 0.0694444444444444
Fw5 l0 w0n Ew5 -0.0694444444444444
Ew6 l6 w6n l0 w0n 0.0694444444444444
Fw6 l0 w0n Ew6 -0.0694444444444444
Ew7 l7 w7n l0 w0n 27.7777777777778
Fw7 l0 w0n Ew7 -27.7777777777778
Ew8 l8 w8n l0 w0n 0.0833333333333333
Fw8 l0 w0n Ew8 -0.0833333333333333
Ew9 l9 w9n l0 w0n 0.0833333333333333
Fw9 l0 w0n Ew9 -0.0833333333333333
Ew10 l10 w10n l0 w0n 0.833333333333333
Fw10 l0 w0n Ew10 -0.833333333333333
Ew11 l11 w11n l0 w0n 0.194444444444444
Fw11 l0 w0n Ew11 -0.194444444444444
Ew12 l12 w12n l0 w0n 0.194444444444444
Fw12 l0 w0n Ew12 -0.194444444444444
Ew13 l13 w13n l0 w0n 0.194444444444444
Fw13 l0 w0n Ew13 -0.194444444444444
Ew14 l14 w14n l0 w0n 0.194444444444444
Fw14 l0 w0n Ew14 -0.194444444444444
Cflux flux_b 0 1 IC=0
Rflux flux_b 0 1e12
Bflux 0 flux_b I={185.185185185185*v(l0,w0n)}
Bprimary l0 w0n I={(0.00222222222222222)*(5000*v(flux_b)+(20000)*(v(flux_b)+.5*(sqrt((v(flux_b)-0.2)^2+1e-10)-sqrt((v(flux_b)+0.2)^2+1e-10)))+(508333.333333333)*(v(flux_b)+.5*(sqrt((v(flux_b)-0.32)^2+1e-10)-sqrt((v(flux_b)+0.32)^2+1e-10))))}
Rloss l0 w0n 10000
.ends T3_CANDIDATE_CORE
.subckt T3_CANDIDATE X2_7 X2_10 X2_11 X2_12 X2_13 X2_4 X2_5 X2_6 X2_3 X1_16 X1_1 X1_2 X1_3 X1_5 X1_7 X1_9 X1_12 X1_13 X1_10 X1_15
Xshared X2_7 X2_10 X2_10 X2_11 X2_11 X2_12 X2_12 X2_13 X2_13 X2_4 X2_5 X2_6 X2_6 X2_3 X1_16 X1_1 X1_2 X1_3 X1_3 X1_5 X1_5 X1_7 X1_9 X1_12 X1_12 X1_13 X1_13 X1_10 X1_10 X1_15 T3_CANDIDATE_CORE
.ends T3_CANDIDATE

* Uncalibrated coupled CRT load; th/tc are temperature rise, not exposed electrical nodes.
.subckt CRT_THERMAL heater_p heater_n cathode g1 g2 anode th tc
Vheater heater_p heater_i 0
Bheater heater_i heater_n I={v(heater_i,heater_n)/(20.0*max(1+0.008*v(th),.1))}
Bheat 0 th I={v(heater_i,heater_n)^2/(20.0*max(1+0.008*v(th),.1))}
Ch th 0 0.02 IC=893.9780984698904
Cc tc 0 0.05 IC=669.1359489252557
Vholdh th 0 893.9780984698904
Vholdc tc 0 669.1359489252557
Rhc th tc 500.0
Rha th 0 5000.0
Rca tc 0 1666.6666666666667
Bhrad th 0 I={5.670374419e-8*1e-06*((v(th)+293.15)^4-293.15^4)}
Bcrad tc 0 I={5.670374419e-8*1e-06*((v(tc)+293.15)^4-293.15^4)}
* Diagnostic current-valued voltages are not physical energy-storage nodes.
Blaunch launch_current 0 V={min(6e-05*(max(v(tc)+293.15,1)/1000.0)^2*exp(min(60,1.1/8.617333262e-5*(1/1000.0-1/(max(v(tc)+293.15,1))))),1e-06*max(v(g1,cathode)+v(g2,cathode)/10.0,0)^1.5)*min(max(v(anode,cathode)/1000.0,0),1)*(1-0.03)}
Bemitted emitted_current 0 V={v(launch_current)+(min(6e-05*(max(v(tc)+293.15,1)/1000.0)^2*exp(min(60,1.1/8.617333262e-5*(1/1000.0-1/(max(v(tc)+293.15,1))))),1e-06*max(v(g1,cathode)+v(g2,cathode)/10.0,0)^1.5)*0.03*min(max(v(g2,cathode),0),1))}

Bbeam anode cathode I={v(launch_current)}
Bg2 g2 cathode I={min(6e-05*(max(v(tc)+293.15,1)/1000.0)^2*exp(min(60,1.1/8.617333262e-5*(1/1000.0-1/(max(v(tc)+293.15,1))))),1e-06*max(v(g1,cathode)+v(g2,cathode)/10.0,0)^1.5)*0.03*min(max(v(g2,cathode),0),1)}
Csocket cathode 0 2e-11
.ends CRT_THERMAL

Vlogic_video logic_video computer_return PWL(0 0 0.0173126445759259 0 0.0173126446759259 1 0.0173129339277778 1 0.0173129340277778 0 0.0173132956175926 0 0.0173132957175926 1 0.0173135126314815 1 0.0173135127314815 0 0.0173137296453704 0 0.0173137297453704 1 0.0173140913351852 1 0.0173140914351852 0 0.0173149593907407 0 0.0173149594907407 1 0.0173153210805556 1 0.0173153211805556 0 0.0173161167981481 0 0.0173161168981481 1 0.01731640615 1 0.01731640625 0 0.017318359275 0 0.017318359375 1 0.017318431612963 1 0.017318431712963 0 0.0173190103166667 0 0.0173190104166667 1 0.0173192996685185 1 0.0173192997685185 0 0.0173196613583333 0 0.0173196614583333 1 0.0173198060342593 1 0.0173198061342593 0 0.0173200953861111 0 0.0173200954861111 1 0.017320384737963 1 0.017320384837963 0 0.0173206740898148 0 0.0173206741898148 1 0.0173211081175926 1 0.0173211082175926 0 0.0173212527935185 0 0.0173212528935185 1 0.0173216144833333 1 0.0173216145833333 0 0.0173229889046296 0 0.0173229890046296 1 0.0173233505944444 1 0.0173233506944444 0 0.0173237122842593 0 0.0173237123842593 1 0.0173239292981481 1 0.0173239293981481 0 0.0173249420296296 0 0.0173249421296296 1 0.0173250143675926 1 0.0173250144675926 0 0.0173253037194444 0 0.0173253038194444 1 0.0173257377472222 1 0.0173257378472222 0 0.017326099437037 0 0.017326099537037 1 0.017326171775 1 0.017326171875 0 0.0173264611268518 0 0.0173264612268519 1 0.0173268951546296 1 0.0173268952546296 0 0.0173270398305556 0 0.0173270399305556 1 0.0173271121685185 1 0.0173271122685185 0 0.0173274015203704 0 0.0173274016203704 1 0.0173274738583333 1 0.0173274739583333 0 0.017375072237963 0 0.017375072337963 1 0.0173751445759259 1 0.0173751446759259 0 0.0173754339277778 0 0.0173754340277778 1 0.0173755062657407 1 0.0173755063657407 0 0.0173757232796296 0 0.0173757233796296 1 0.0173757956175926 1 0.0173757957175926 0 0.0173760126314815 0 0.0173760127314815 1 0.0173760849694444 1 0.0173760850694444 0 0.0173762296453704 0 0.0173762297453704 1 0.0173763019833333 1 0.0173763020833333 0 0.0173765913351852 0 0.0173765914351852 1 0.0173766636731481 1 0.0173766637731481 0 0.0173776764046296 0 0.0173776765046296 1 0.0173777487425926 1 0.0173777488425926 0 0.0173785444601852 0 0.0173785445601852 1 0.0173786167981481 1 0.0173786168981481 0 0.01737890615 0 0.01737890625 1 0.017378978487963 1 0.017378978587963 0 0.017380859275 0 0.017380859375 1 0.017380931612963 1 0.017380931712963 0 0.0173814379787037 0 0.0173814380787037 1 0.0173815103166667 1 0.0173815104166667 0 0.0173817996685185 0 0.0173817997685185 1 0.0173818720064815 1 0.0173818721064815 0 0.0173820890203704 0 0.0173820891203704 1 0.0173821613583333 1 0.0173821614583333 0 0.0173823060342593 0 0.0173823061342593 1 0.0173823783722222 1 0.0173823784722222 0 0.0173825953861111 0 0.0173825954861111 1 0.0173826677240741 1 0.0173826678240741 0 0.017382884737963 0 0.017382884837963 1 0.0173829570759259 1 0.0173829571759259 0 0.0173831740898148 0 0.0173831741898148 1 0.0173832464277778 1 0.0173832465277778 0 0.0173837527935185 0 0.0173837528935185 1 0.0173838251314815 1 0.0173838252314815 0 0.0173841144833333 0 0.0173841145833333 1 0.0173841868212963 1 0.0173841869212963 0 0.0173854889046296 0 0.0173854890046296 1 0.0173855612425926 1 0.0173855613425926 0 0.0173858505944444 0 0.0173858506944444 1 0.0173859229324074 1 0.0173859230324074 0 0.0173861399462963 0 0.0173861400462963 1 0.0173862122842593 1 0.0173862123842593 0 0.0173864292981481 0 0.0173864293981481 1 0.0173865016361111 1 0.0173865017361111 0 0.0173873696916667 0 0.0173873697916667 1 0.0173875143675926 1 0.0173875144675926 0 0.0173881654092593 0 0.0173881655092593 1 0.0173882377472222 1 0.0173882378472222 0 0.0173885270990741 0 0.0173885271990741 1 0.017388671775 1 0.017388671875 0 0.0173889611268518 0 0.0173889612268519 1 0.0173890334648148 1 0.0173890335648148 0 0.0173895398305556 0 0.0173895399305556 1 0.0173896121685185 1 0.0173896122685185 0 0.0173899015203704 0 0.0173899016203704 1 0.0173899738583333 1 0.0173899739583333 0 0.017437572237963 0 0.017437572337963 1 0.0174376445759259 1 0.0174376446759259 0 0.0174381509416667 0 0.0174381510416667 1 0.0174382232796296 1 0.0174382233796296 0 0.0174387296453704 0 0.0174387297453704 1 0.0174388019833333 1 0.0174388020833333 0 0.0174390913351852 0 0.0174390914351852 1 0.0174391636731481 1 0.0174391637731481 0 0.0174401040666667 0 0.0174401041666667 1 0.0174401764046296 1 0.0174401765046296 0 0.0174410444601852 0 0.0174410445601852 1 0.0174411167981481 1 0.0174411168981481 0 0.017441333812037 0 0.017441333912037 1 0.017441478487963 1 0.017441478587963 0 0.017443359275 0 0.017443359375 1 0.017443431612963 1 0.017443431712963 0 0.0174439379787037 0 0.0174439380787037 1 0.0174440103166667 1 0.0174440104166667 0 0.0174442996685185 0 0.0174442997685185 1 0.0174443720064815 1 0.0174443721064815 0 0.0174445166824074 0 0.0174445167824074 1 0.0174445890203704 1 0.0174445891203704 0 0.0174448783722222 0 0.0174448784722222 1 0.0174449507101852 1 0.0174449508101852 0 0.0174450953861111 0 0.0174450954861111 1 0.0174451677240741 1 0.0174451678240741 0 0.0174454570759259 0 0.0174454571759259 1 0.0174455294138889 1 0.0174455295138889 0 0.0174456740898148 0 0.0174456741898148 1 0.0174457464277778 1 0.0174457465277778 0 0.0174462527935185 0 0.0174462528935185 1 0.0174463251314815 1 0.0174463252314815 0 0.0174466144833333 0 0.0174466145833333 1 0.0174466868212963 1 0.0174466869212963 0 0.0174479889046296 0 0.0174479890046296 1 0.0174480612425926 1 0.0174480613425926 0 0.0174483505944444 0 0.0174483506944444 1 0.0174484229324074 1 0.0174484230324074 0 0.0174485676083333 0 0.0174485677083333 1 0.0174486399462963 1 0.0174486400462963 0 0.0174497973537037 0 0.0174497974537037 1 0.0174498696916667 1 0.0174498697916667 0 0.0174499420296296 0 0.0174499421296296 1 0.0174500143675926 1 0.0174500144675926 0 0.0174505930712963 0 0.0174505931712963 1 0.0174506654092593 1 0.0174506655092593 0 0.0174509547611111 0 0.0174509548611111 1 0.0174510270990741 1 0.0174510271990741 0 0.017451099437037 0 0.017451099537037 1 0.017451171775 1 0.017451171875 0 0.0174514611268518 0 0.0174514612268519 1 0.0174515334648148 1 0.0174515335648148 0 0.0174520398305556 0 0.0174520399305556 1 0.0174521121685185 1 0.0174521122685185 0 0.0174524015203704 0 0.0174524016203704 1 0.0174524738583333 1 0.0174524739583333 0 0.017500072237963 0 0.017500072337963 1 0.0175001445759259 1 0.0175001446759259 0 0.0175006509416667 0 0.0175006510416667 1 0.0175007232796296 1 0.0175007233796296 0 0.0175012296453704 0 0.0175012297453704 1 0.0175013019833333 1 0.0175013020833333 0 0.0175015913351852 0 0.0175015914351852 1 0.0175016636731481 1 0.0175016637731481 0 0.0175025317287037 0 0.0175025318287037 1 0.0175026764046296 1 0.0175026765046296 0 0.0175035444601852 0 0.0175035445601852 1 0.0175036167981481 1 0.0175036168981481 0 0.0175037614740741 0 0.0175037615740741 1 0.017503833812037 1 0.017503833912037 0 0.01750390615 0 0.01750390625 1 0.017503978487963 1 0.017503978587963 0 0.017505859275 0 0.017505859375 1 0.017505931612963 1 0.017505931712963 0 0.0175064379787037 0 0.0175064380787037 1 0.0175065103166667 1 0.0175065104166667 0 0.0175067996685185 0 0.0175067997685185 1 0.0175068720064815 1 0.0175068721064815 0 0.0175070166824074 0 0.0175070167824074 1 0.0175070890203704 1 0.0175070891203704 0 0.0175073783722222 0 0.0175073784722222 1 0.0175074507101852 1 0.0175074508101852 0 0.0175075953861111 0 0.0175075954861111 1 0.0175076677240741 1 0.0175076678240741 0 0.0175079570759259 0 0.0175079571759259 1 0.0175080294138889 1 0.0175080295138889 0 0.0175081740898148 0 0.0175081741898148 1 0.0175082464277778 1 0.0175082465277778 0 0.0175087527935185 0 0.0175087528935185 1 0.0175088251314815 1 0.0175088252314815 0 0.0175091144833333 0 0.0175091145833333 1 0.0175091868212963 1 0.0175091869212963 0 0.0175104889046296 0 0.0175104890046296 1 0.0175105612425926 1 0.0175105613425926 0 0.0175108505944444 0 0.0175108506944444 1 0.0175109229324074 1 0.0175109230324074 0 0.0175110676083333 0 0.0175110677083333 1 0.0175111399462963 1 0.0175111400462963 0 0.0175124420296296 0 0.0175124421296296 1 0.0175125143675926 1 0.0175125144675926 0 0.0175130207333333 0 0.0175130208333333 1 0.0175130930712963 1 0.0175130931712963 0 0.017513599437037 0 0.017513599537037 1 0.017513671775 1 0.017513671875 0 0.0175139611268518 0 0.0175139612268519 1 0.0175142504787037 1 0.0175142505787037 0 0.0175145398305556 0 0.0175145399305556 1 0.0175146121685185 1 0.0175146122685185 0 0.0175149015203704 0 0.0175149016203704 1 0.0175149738583333 1 0.0175149739583333 0 0.0175626445759259 0 0.0175626446759259 1 0.0175629339277778 1 0.0175629340277778 0 0.0175631509416667 0 0.0175631510416667 1 0.0175632232796296 1 0.0175632233796296 0 0.0175637296453704 0 0.0175637297453704 1 0.0175640913351852 1 0.0175640914351852 0 0.0175651764046296 0 0.0175651765046296 1 0.0175652487425926 1 0.0175652488425926 0 0.0175660444601852 0 0.0175660445601852 1 0.0175661167981481 1 0.0175661168981481 0 0.0175661891361111 0 0.0175661892361111 1 0.0175662614740741 1 0.0175662615740741 0 0.01756640615 0 0.01756640625 1 0.017566478487963 1 0.017566478587963 0 0.0175672018675926 0 0.0175672019675926 1 0.0175675635574074 1 0.0175675636574074 0 0.017568359275 0 0.017568359375 1 0.017568431612963 1 0.017568431712963 0 0.0175689379787037 0 0.0175689380787037 1 0.0175690103166667 1 0.0175690104166667 0 0.0175692996685185 0 0.0175692997685185 1 0.0175693720064815 1 0.0175693721064815 0 0.0175695166824074 0 0.0175695167824074 1 0.0175695890203704 1 0.0175695891203704 0 0.0175698783722222 0 0.0175698784722222 1 0.0175699507101852 1 0.0175699508101852 0 0.0175700953861111 0 0.0175700954861111 1 0.0175701677240741 1 0.0175701678240741 0 0.0175704570759259 0 0.0175704571759259 1 0.0175705294138889 1 0.0175705295138889 0 0.0175706740898148 0 0.0175706741898148 1 0.0175709634416667 1 0.0175709635416667 0 0.0175712527935185 0 0.0175712528935185 1 0.0175716144833333 1 0.0175716145833333 0 0.0175729889046296 0 0.0175729890046296 1 0.0175733505944444 1 0.0175733506944444 0 0.0175735676083333 0 0.0175735677083333 1 0.0175736399462963 1 0.0175736400462963 0 0.0175749420296296 0 0.0175749421296296 1 0.0175750143675926 1 0.0175750144675926 0 0.0175754483953704 0 0.0175754484953704 1 0.0175755207333333 1 0.0175755208333333 0 0.017576099437037 0 0.017576099537037 1 0.017576171775 1 0.017576171875 0 0.0175767504787037 0 0.0175767505787037 1 0.0175768228166667 1 0.0175768229166667 0 0.0175770398305556 0 0.0175770399305556 1 0.0175771121685185 1 0.0175771122685185 0 0.0175774015203704 0 0.0175774016203704 1 0.0175774738583333 1 0.0175774739583333 0 0.0176254339277778 0 0.0176254340277778 1 0.0176255062657407 1 0.0176255063657407 0 0.0176256509416667 0 0.0176256510416667 1 0.0176257232796296 1 0.0176257233796296 0 0.0176262296453704 0 0.0176262297453704 1 0.0176263019833333 1 0.0176263020833333 0 0.0176277487425926 0 0.0176277488425926 1 0.0176278210805556 1 0.0176278211805556 0 0.0176285444601852 0 0.0176285445601852 1 0.0176286891361111 1 0.0176286892361111 0 0.01762890615 0 0.01762890625 1 0.017628978487963 1 0.017628978587963 0 0.017630859275 0 0.017630859375 1 0.017630931612963 1 0.017630931712963 0 0.0176314379787037 0 0.0176314380787037 1 0.0176315103166667 1 0.0176315104166667 0 0.0176317996685185 0 0.0176317997685185 1 0.0176318720064815 1 0.0176318721064815 0 0.0176320166824074 0 0.0176320167824074 1 0.0176324507101852 1 0.0176324508101852 0 0.0176325953861111 0 0.0176325954861111 1 0.0176326677240741 1 0.0176326678240741 0 0.0176329570759259 0 0.0176329571759259 1 0.0176330294138889 1 0.0176330295138889 0 0.0176331740898148 0 0.0176331741898148 1 0.0176332464277778 1 0.0176332465277778 0 0.0176337527935185 0 0.0176337528935185 1 0.0176338251314815 1 0.0176338252314815 0 0.0176338974694444 0 0.0176338975694444 1 0.0176339698074074 1 0.0176339699074074 0 0.0176354889046296 0 0.0176354890046296 1 0.0176355612425926 1 0.0176355613425926 0 0.0176360676083333 0 0.0176360677083333 1 0.0176361399462963 1 0.0176361400462963 0 0.0176374420296296 0 0.0176374421296296 1 0.0176375143675926 1 0.0176375144675926 0 0.0176379483953704 0 0.0176379484953704 1 0.0176380207333333 1 0.0176380208333333 0 0.017638599437037 0 0.017638599537037 1 0.017638671775 1 0.017638671875 0 0.0176393228166667 0 0.0176393229166667 1 0.0176393951546296 1 0.0176393952546296 0 0.0176395398305556 0 0.0176395399305556 1 0.0176396121685185 1 0.0176396122685185 0 0.0176399015203704 0 0.0176399016203704 1 0.0176399738583333 1 0.0176399739583333 0 0.0176879339277778 0 0.0176879340277778 1 0.0176880062657407 1 0.0176880063657407 0 0.0176881509416667 0 0.0176881510416667 1 0.0176882232796296 1 0.0176882233796296 0 0.0176887296453704 0 0.0176887297453704 1 0.0176888019833333 1 0.0176888020833333 0 0.0176902487425926 0 0.0176902488425926 1 0.0176903210805556 1 0.0176903211805556 0 0.0176910444601852 0 0.0176910445601852 1 0.0176911167981481 1 0.0176911168981481 0 0.01769140615 0 0.01769140625 1 0.017691478487963 1 0.017691478587963 0 0.017693359275 0 0.017693359375 1 0.017693431612963 1 0.017693431712963 0 0.0176939379787037 0 0.0176939380787037 1 0.0176940103166667 1 0.0176940104166667 0 0.0176942996685185 0 0.0176942997685185 1 0.0176943720064815 1 0.0176943721064815 0 0.0176945166824074 0 0.0176945167824074 1 0.0176945890203704 1 0.0176945891203704 0 0.0176948783722222 0 0.0176948784722222 1 0.0176949507101852 1 0.0176949508101852 0 0.0176950953861111 0 0.0176950954861111 1 0.0176951677240741 1 0.0176951678240741 0 0.0176954570759259 0 0.0176954571759259 1 0.0176955294138889 1 0.0176955295138889 0 0.0176956740898148 0 0.0176956741898148 1 0.0176957464277778 1 0.0176957465277778 0 0.0176962527935185 0 0.0176962528935185 1 0.0176963251314815 1 0.0176963252314815 0 0.0176964698074074 0 0.0176964699074074 1 0.0176965421453704 1 0.0176965422453704 0 0.0176979889046296 0 0.0176979890046296 1 0.0176980612425926 1 0.0176980613425926 0 0.0176985676083333 0 0.0176985677083333 1 0.0176986399462963 1 0.0176986400462963 0 0.0176999420296296 0 0.0176999421296296 1 0.0177000143675926 1 0.0177000144675926 0 0.0177004483953704 0 0.0177004484953704 1 0.0177005207333333 1 0.0177005208333333 0 0.017701099437037 0 0.017701099537037 1 0.017701171775 1 0.017701171875 0 0.0177018228166667 0 0.0177018229166667 1 0.0177018951546296 1 0.0177018952546296 0 0.0177020398305556 0 0.0177020399305556 1 0.0177021121685185 1 0.0177021122685185 0 0.0177021845064815 0 0.0177021846064815 1 0.0177023291824074 1 0.0177023292824074 0 0.0177024015203704 0 0.0177024016203704 1 0.0177024738583333 1 0.0177024739583333 0 0.017750072237963 0 0.017750072337963 1 0.0177501445759259 1 0.0177501446759259 0 0.0177504339277778 0 0.0177504340277778 1 0.0177505062657407 1 0.0177505063657407 0 0.0177507232796296 0 0.0177507233796296 1 0.0177507956175926 1 0.0177507957175926 0 0.0177510126314815 0 0.0177510127314815 1 0.0177510849694444 1 0.0177510850694444 0 0.0177512296453704 0 0.0177512297453704 1 0.0177513019833333 1 0.0177513020833333 0 0.0177523870527778 0 0.0177523871527778 1 0.0177524593907407 1 0.0177524594907407 0 0.0177526764046296 0 0.0177526765046296 1 0.0177527487425926 1 0.0177527488425926 0 0.0177535444601852 0 0.0177535445601852 1 0.0177536167981481 1 0.0177536168981481 0 0.01775390615 0 0.01775390625 1 0.017753978487963 1 0.017753978587963 0 0.017755859275 0 0.017755859375 1 0.017755931612963 1 0.017755931712963 0 0.0177564379787037 0 0.0177564380787037 1 0.0177565103166667 1 0.0177565104166667 0 0.0177567996685185 0 0.0177567997685185 1 0.0177568720064815 1 0.0177568721064815 0 0.0177570166824074 0 0.0177570167824074 1 0.0177570890203704 1 0.0177570891203704 0 0.0177573783722222 0 0.0177573784722222 1 0.0177574507101852 1 0.0177574508101852 0 0.0177575953861111 0 0.0177575954861111 1 0.0177576677240741 1 0.0177576678240741 0 0.017757884737963 0 0.017757884837963 1 0.0177579570759259 1 0.0177579571759259 0 0.0177581740898148 0 0.0177581741898148 1 0.0177582464277778 1 0.0177582465277778 0 0.0177587527935185 0 0.0177587528935185 1 0.0177588251314815 1 0.0177588252314815 0 0.0177590421453704 0 0.0177590422453704 1 0.0177591144833333 1 0.0177591145833333 0 0.0177604889046296 0 0.0177604890046296 1 0.0177605612425926 1 0.0177605613425926 0 0.0177611399462963 0 0.0177611400462963 1 0.0177612122842593 1 0.0177612123842593 0 0.0177614292981481 0 0.0177614293981481 1 0.0177615016361111 1 0.0177615017361111 0 0.0177624420296296 0 0.0177624421296296 1 0.0177625143675926 1 0.0177625144675926 0 0.0177629483953704 0 0.0177629484953704 1 0.0177630207333333 1 0.0177630208333333 0 0.017763599437037 0 0.017763599537037 1 0.017763671775 1 0.017763671875 0 0.0177642504787037 0 0.0177642505787037 1 0.0177643228166667 1 0.0177643229166667 0 0.0177645398305556 0 0.0177645399305556 1 0.0177646121685185 1 0.0177646122685185 0 0.0177646845064815 0 0.0177646846064815 1 0.0177648291824074 1 0.0177648292824074 0 0.0177649015203704 0 0.0177649016203704 1 0.0177649738583333 1 0.0177649739583333 0 0.0178126445759259 0 0.0178126446759259 1 0.0178129339277778 1 0.0178129340277778 0 0.0178132956175926 0 0.0178132957175926 1 0.0178135126314815 1 0.0178135127314815 0 0.0178137296453704 0 0.0178137297453704 1 0.0178138019833333 1 0.0178138020833333 0 0.0178149593907407 0 0.0178149594907407 1 0.0178151764046296 1 0.0178151765046296 0 0.0178156104324074 0 0.0178156105324074 1 0.0178156827703704 1 0.0178156828703704 0 0.0178161167981481 0 0.0178161168981481 1 0.01781640615 1 0.01781640625 0 0.017818359275 0 0.017818359375 1 0.0178187933027778 1 0.0178187934027778 0 0.0178190103166667 0 0.0178190104166667 1 0.0178192996685185 1 0.0178192997685185 0 0.0178195166824074 0 0.0178195167824074 1 0.0178195890203704 1 0.0178195891203704 0 0.0178198783722222 0 0.0178198784722222 1 0.0178199507101852 1 0.0178199508101852 0 0.0178200953861111 0 0.0178200954861111 1 0.017820384737963 1 0.017820384837963 0 0.0178206740898148 0 0.0178206741898148 1 0.0178211081175926 1 0.0178211082175926 0 0.0178212527935185 0 0.0178212528935185 1 0.0178213251314815 1 0.0178213252314815 0 0.0178216144833333 0 0.0178216145833333 1 0.0178216868212963 1 0.0178216869212963 0 0.0178229889046296 0 0.0178229890046296 1 0.0178230612425926 1 0.0178230613425926 0 0.0178237122842593 0 0.0178237123842593 1 0.0178239292981481 1 0.0178239293981481 0 0.0178249420296296 0 0.0178249421296296 1 0.0178250143675926 1 0.0178250144675926 0 0.0178254483953704 0 0.0178254484953704 1 0.0178255207333333 1 0.0178255208333333 0 0.017826099437037 0 0.017826099537037 1 0.017826171775 1 0.017826171875 0 0.0178264611268519 0 0.0178264612268519 1 0.0178267504787037 1 0.0178267505787037 0 0.0178271121685185 0 0.0178271122685185 1 0.0178271845064815 1 0.0178271846064815 0 0.0178273291824074 0 0.0178273292824074 1 0.0178274015203704 1 0.0178274016203704 0 0.018062572237963 0 0.018062572337963 1 0.0180626445759259 1 0.0180626446759259 0 0.0180629339277778 0 0.0180629340277778 1 0.0180630062657407 1 0.0180630063657407 0 0.0180632232796296 0 0.0180632233796296 1 0.0180635126314815 1 0.0180635127314815 0 0.0180638019833333 0 0.0180638020833333 1 0.0180640913351852 1 0.0180640914351852 0 0.018064380687037 0 0.018064380787037 1 0.0180646700388889 1 0.0180646701388889 0 0.0180651040666667 0 0.0180651041666667 1 0.0180651764046296 1 0.0180651765046296 0 0.018068431612963 0 0.018068431712963 1 0.0180687209648148 1 0.0180687210648148 0 0.0180689379787037 0 0.0180689380787037 1 0.0180693720064815 1 0.0180693721064815 0 0.0180701677240741 0 0.0180701678240741 1 0.0180704570759259 1 0.0180704571759259 0 0.0180706740898148 0 0.0180706741898148 1 0.0180711081175926 1 0.0180711082175926 0 0.0180719038351852 0 0.0180719039351852 1 0.0180721208490741 1 0.0180721209490741 0 0.0180724102009259 0 0.0180724103009259 1 0.0180728442287037 1 0.0180728443287037 0 0.0180749420296296 0 0.0180749421296296 1 0.0180750143675926 1 0.0180750144675926 0 0.0180754483953704 0 0.0180754484953704 1 0.0180756654092593 1 0.0180756655092593 0 0.0180759547611111 0 0.0180759548611111 1 0.0180760270990741 1 0.0180760271990741 0 0.0180770398305556 0 0.0180770399305556 1 0.0180774015203704 1 0.0180774016203704 0 0.018078197237963 0 0.018078197337963 1 0.0180784865898148 1 0.0180784866898148 0 0.0180787759416667 0 0.0180787760416667 1 0.0180788482796296 1 0.0180788483796296 0 0.0180791376314815 0 0.0180791377314815 1 0.0180792099694444 1 0.0180792100694444 0 0.0180794269833333 0 0.0180794270833333 1 0.0180797163351852 1 0.0180797164351852 0 0.018125072237963 0 0.018125072337963 1 0.0181251445759259 1 0.0181251446759259 0 0.0181254339277778 0 0.0181254340277778 1 0.0181255062657407 1 0.0181255063657407 0 0.0181256509416667 0 0.0181256510416667 1 0.0181257232796296 1 0.0181257233796296 0 0.0181260126314815 0 0.0181260127314815 1 0.0181260849694444 1 0.0181260850694444 0 0.0181262296453704 0 0.0181262297453704 1 0.0181263019833333 1 0.0181263020833333 0 0.0181265913351852 0 0.0181265914351852 1 0.0181266636731481 1 0.0181266637731481 0 0.0181268083490741 0 0.0181268084490741 1 0.018126880687037 1 0.018126880787037 0 0.0181271700388889 0 0.0181271701388889 1 0.0181272423768519 1 0.0181272424768519 0 0.0181275317287037 0 0.0181275318287037 1 0.0181276764046296 1 0.0181276765046296 0 0.018130859275 0 0.018130859375 1 0.018130931612963 1 0.018130931712963 0 0.0181312209648148 0 0.0181312210648148 1 0.0181312933027778 1 0.0181312934027778 0 0.0181314379787037 0 0.0181314380787037 1 0.0181315103166667 1 0.0181315104166667 0 0.0181325953861111 0 0.0181325954861111 1 0.0181326677240741 1 0.0181326678240741 0 0.0181329570759259 0 0.0181329571759259 1 0.0181330294138889 1 0.0181330295138889 0 0.0181331740898148 0 0.0181331741898148 1 0.0181332464277778 1 0.0181332465277778 0 0.0181343314972222 0 0.0181343315972222 1 0.0181344038351852 1 0.0181344039351852 0 0.0181346208490741 0 0.0181346209490741 1 0.018134693187037 1 0.018134693287037 0 0.0181352718907407 0 0.0181352719907407 1 0.0181353442287037 1 0.0181353443287037 0 0.0181373696916667 0 0.0181373697916667 1 0.0181374420296296 1 0.0181374421296296 0 0.0181378760574074 0 0.0181378761574074 1 0.0181379483953704 1 0.0181379484953704 0 0.0181381654092593 0 0.0181381655092593 1 0.0181382377472222 1 0.0181382378472222 0 0.0181385270990741 0 0.0181385271990741 1 0.018138599437037 1 0.018138599537037 0 0.0181395398305556 0 0.0181395399305556 1 0.0181396121685185 1 0.0181396122685185 0 0.0181399015203704 0 0.0181399016203704 1 0.0181399738583333 1 0.0181399739583333 0 0.018140697237963 0 0.018140697337963 1 0.0181407695759259 1 0.0181407696759259 0 0.0181409865898148 0 0.0181409866898148 1 0.0181410589277778 1 0.0181410590277778 0 0.0181412759416667 0 0.0181412760416667 1 0.0181413482796296 1 0.0181413483796296 0 0.0181416376314815 0 0.0181416377314815 1 0.0181417099694444 1 0.0181417100694444 0 0.0181418546453704 0 0.0181418547453704 1 0.0181419269833333 1 0.0181419270833333 0 0.0181422163351852 0 0.0181422164351852 1 0.0181422886731481 1 0.0181422887731481 0 0.018187572237963 0 0.018187572337963 1 0.0181876445759259 1 0.0181876446759259 0 0.0181879339277778 0 0.0181879340277778 1 0.0181880062657407 1 0.0181880063657407 0 0.0181881509416667 0 0.0181881510416667 1 0.0181882232796296 1 0.0181882233796296 0 0.0181884402935185 0 0.0181884403935185 1 0.0181885849694444 1 0.0181885850694444 0 0.0181887296453704 0 0.0181887297453704 1 0.0181888019833333 1 0.0181888020833333 0 0.0181890189972222 0 0.0181890190972222 1 0.0181891636731481 1 0.0181891637731481 0 0.0181893083490741 0 0.0181893084490741 1 0.018189380687037 1 0.018189380787037 0 0.0181895977009259 0 0.0181895978009259 1 0.0181897423768519 1 0.0181897424768519 0 0.0181899593907407 0 0.0181899594907407 1 0.0181900317287037 1 0.0181900318287037 0 0.0181901040666667 0 0.0181901041666667 1 0.0181901764046296 1 0.0181901765046296 0 0.0181937209648148 0 0.0181937210648148 1 0.0181937933027778 1 0.0181937934027778 0 0.0181939379787037 0 0.0181939380787037 1 0.0181940103166667 1 0.0181940104166667 0 0.0181948783722222 0 0.0181948784722222 1 0.0181949507101852 1 0.0181949508101852 0 0.0181950953861111 0 0.0181950954861111 1 0.0181951677240741 1 0.0181951678240741 0 0.018195384737963 0 0.018195384837963 1 0.0181955294138889 1 0.0181955295138889 0 0.0181956740898148 0 0.0181956741898148 1 0.0181957464277778 1 0.0181957465277778 0 0.0181966144833333 0 0.0181966145833333 1 0.0181966868212963 1 0.0181966869212963 0 0.0181968314972222 0 0.0181968315972222 1 0.0181969038351852 1 0.0181969039351852 0 0.0181971208490741 0 0.0181971209490741 1 0.018197193187037 1 0.018197193287037 0 0.0181976995527778 0 0.0181976996527778 1 0.0181977718907407 1 0.0181977719907407 0 0.0181997973537037 0 0.0181997974537037 1 0.0181998696916667 1 0.0181998697916667 0 0.0182003037194444 0 0.0182003038194444 1 0.0182003760574074 1 0.0182003761574074 0 0.018201099437037 0 0.018201099537037 1 0.018201171775 1 0.018201171875 0 0.0182020398305556 0 0.0182020399305556 1 0.0182021121685185 1 0.0182021122685185 0 0.0182024015203704 0 0.0182024016203704 1 0.0182024738583333 1 0.0182024739583333 0 0.018203197237963 0 0.018203197337963 1 0.0182032695759259 1 0.0182032696759259 0 0.0182035589277778 0 0.0182035590277778 1 0.0182036312657407 1 0.0182036313657407 0 0.0182037759416667 0 0.0182037760416667 1 0.0182038482796296 1 0.0182038483796296 0 0.0182041376314815 0 0.0182041377314815 1 0.0182042099694444 1 0.0182042100694444 0 0.0182043546453704 0 0.0182043547453704 1 0.0182044269833333 1 0.0182044270833333 0 0.018250072237963 0 0.018250072337963 1 0.0182501445759259 1 0.0182501446759259 0 0.0182504339277778 0 0.0182504340277778 1 0.0182505062657407 1 0.0182505063657407 0 0.0182506509416667 0 0.0182506510416667 1 0.0182507232796296 1 0.0182507233796296 0 0.0182508679555556 0 0.0182508680555556 1 0.0182509402935185 1 0.0182509403935185 0 0.0182510126314815 0 0.0182510127314815 1 0.0182510849694444 1 0.0182510850694444 0 0.0182512296453704 0 0.0182512297453704 1 0.0182513019833333 1 0.0182513020833333 0 0.0182514466592593 0 0.0182514467592593 1 0.0182515189972222 1 0.0182515190972222 0 0.0182515913351852 0 0.0182515914351852 1 0.0182516636731481 1 0.0182516637731481 0 0.0182518083490741 0 0.0182518084490741 1 0.018251880687037 1 0.018251880787037 0 0.018252025362963 0 0.018252025462963 1 0.0182520977009259 1 0.0182520978009259 0 0.0182521700388889 0 0.0182521701388889 1 0.0182522423768519 1 0.0182522424768519 0 0.0182526040666667 0 0.0182526041666667 1 0.0182526764046296 1 0.0182526765046296 0 0.0182561486268519 0 0.0182561487268519 1 0.0182562209648148 1 0.0182562210648148 0 0.0182564379787037 0 0.0182564380787037 1 0.0182567273305556 1 0.0182567274305556 0 0.0182573060342593 0 0.0182573061342593 1 0.0182573783722222 1 0.0182573784722222 0 0.0182575953861111 0 0.0182575954861111 1 0.0182576677240741 1 0.0182576678240741 0 0.0182578124 0 0.0182578125 1 0.018257884737963 1 0.018257884837963 0 0.0182579570759259 0 0.0182579571759259 1 0.0182580294138889 1 0.0182580295138889 0 0.0182581740898148 0 0.0182581741898148 1 0.0182584634416667 1 0.0182584635416667 0 0.0182590421453704 0 0.0182590422453704 1 0.0182591144833333 1 0.0182591145833333 0 0.0182594038351852 0 0.0182594039351852 1 0.0182596208490741 1 0.0182596209490741 0 0.0182601272148148 0 0.0182601273148148 1 0.0182601995527778 1 0.0182601996527778 0 0.0182622973537037 0 0.0182622974537037 1 0.0182623696916667 1 0.0182623697916667 0 0.0182628037194444 0 0.0182628038194444 1 0.0182628760574074 1 0.0182628761574074 0 0.018263599437037 0 0.018263599537037 1 0.018263671775 1 0.018263671875 0 0.0182645398305556 0 0.0182645399305556 1 0.0182646121685185 1 0.0182646122685185 0 0.0182649015203704 0 0.0182649016203704 1 0.0182649738583333 1 0.0182649739583333 0 0.018265697237963 0 0.018265697337963 1 0.0182657695759259 1 0.0182657696759259 0 0.0182659865898148 0 0.0182659866898148 1 0.0182660589277778 1 0.0182660590277778 0 0.0182662759416667 0 0.0182662760416667 1 0.0182663482796296 1 0.0182663483796296 0 0.0182666376314815 0 0.0182666377314815 1 0.0182667099694444 1 0.0182667100694444 0 0.0182668546453704 0 0.0182668547453704 1 0.0182669269833333 1 0.0182669270833333 0 0.018312572237963 0 0.018312572337963 1 0.0183126445759259 1 0.0183126446759259 0 0.0183129339277778 0 0.0183129340277778 1 0.0183130062657407 1 0.0183130063657407 0 0.0183131509416667 0 0.0183131510416667 1 0.0183132232796296 1 0.0183132233796296 0 0.0183132956175926 0 0.0183132957175926 1 0.0183133679555556 1 0.0183133680555556 0 0.0183135126314815 0 0.0183135127314815 1 0.0183135849694444 1 0.0183135850694444 0 0.0183137296453704 0 0.0183137297453704 1 0.0183138019833333 1 0.0183138020833333 0 0.0183138743212963 0 0.0183138744212963 1 0.0183139466592593 1 0.0183139467592593 0 0.0183140913351852 0 0.0183140914351852 1 0.0183141636731481 1 0.0183141637731481 0 0.0183143083490741 0 0.0183143084490741 1 0.018314380687037 1 0.018314380787037 0 0.018314453025 0 0.018314453125 1 0.018314525362963 1 0.018314525462963 0 0.0183146700388889 0 0.0183146701388889 1 0.0183147423768519 1 0.0183147424768519 0 0.0183151040666667 0 0.0183151041666667 1 0.0183151764046296 1 0.0183151765046296 0 0.0183185762888889 0 0.0183185763888889 1 0.0183186486268519 1 0.0183186487268519 0 0.0183192273305556 0 0.0183192274305556 1 0.0183192996685185 1 0.0183192997685185 0 0.0183197336962963 0 0.0183197337962963 1 0.0183198060342593 1 0.0183198061342593 0 0.0183200953861111 0 0.0183200954861111 1 0.0183201677240741 1 0.0183201678240741 0 0.018320240062037 0 0.018320240162037 1 0.0183203124 1 0.0183203125 0 0.0183204570759259 0 0.0183204571759259 1 0.0183205294138889 1 0.0183205295138889 0 0.0183209634416667 0 0.0183209635416667 1 0.0183210357796296 1 0.0183210358796296 0 0.0183214698074074 0 0.0183214699074074 1 0.0183215421453704 1 0.0183215422453704 0 0.0183218314972222 0 0.0183218315972222 1 0.0183219038351852 1 0.0183219039351852 0 0.0183221208490741 0 0.0183221209490741 1 0.018322193187037 1 0.018322193287037 0 0.0183225548768518 0 0.0183225549768519 1 0.0183226272148148 1 0.0183226273148148 0 0.0183247973537037 0 0.0183247974537037 1 0.0183248696916667 1 0.0183248697916667 0 0.0183253037194444 0 0.0183253038194444 1 0.0183253760574074 1 0.0183253761574074 0 0.018326099437037 0 0.018326099537037 1 0.018326171775 1 0.018326171875 0 0.0183270398305556 0 0.0183270399305556 1 0.0183274015203704 1 0.0183274016203704 0 0.0183276185342593 0 0.0183276186342593 1 0.0183279802240741 1 0.0183279803240741 0 0.018328197237963 0 0.018328197337963 1 0.0183284865898148 1 0.0183284866898148 0 0.0183287759416667 0 0.0183287760416667 1 0.0183288482796296 1 0.0183288483796296 0 0.0183291376314815 0 0.0183291377314815 1 0.0183292099694444 1 0.0183292100694444 0 0.0183294269833333 0 0.0183294270833333 1 0.0183297163351852 1 0.0183297164351852 0 0.018375072237963 0 0.018375072337963 1 0.0183751445759259 1 0.0183751446759259 0 0.0183754339277778 0 0.0183754340277778 1 0.0183755062657407 1 0.0183755063657407 0 0.0183756509416667 0 0.0183756510416667 1 0.0183757956175926 1 0.0183757957175926 0 0.0183760126314815 0 0.0183760127314815 1 0.0183760849694444 1 0.0183760850694444 0 0.0183762296453704 0 0.0183762297453704 1 0.0183763743212963 1 0.0183763744212963 0 0.0183765913351852 0 0.0183765914351852 1 0.0183766636731481 1 0.0183766637731481 0 0.0183768083490741 0 0.0183768084490741 1 0.018376953025 1 0.018376953125 0 0.0183771700388889 0 0.0183771701388889 1 0.0183772423768519 1 0.0183772424768519 0 0.0183776040666667 0 0.0183776041666667 1 0.0183776764046296 1 0.0183776765046296 0 0.0183810039509259 0 0.0183810040509259 1 0.0183810762888889 1 0.0183810763888889 0 0.0183817996685185 0 0.0183817997685185 1 0.0183818720064815 1 0.0183818721064815 0 0.0183821613583333 0 0.0183821614583333 1 0.0183822336962963 1 0.0183822337962963 0 0.0183825953861111 0 0.0183825954861111 1 0.018382740062037 1 0.018382740162037 0 0.0183829570759259 0 0.0183829571759259 1 0.0183830294138889 1 0.0183830295138889 0 0.0183835357796296 0 0.0183835358796296 1 0.0183836081175926 1 0.0183836082175926 0 0.0183838974694444 0 0.0183838975694444 1 0.0183839698074074 1 0.0183839699074074 0 0.0183843314972222 0 0.0183843315972222 1 0.0183844038351852 1 0.0183844039351852 0 0.0183846208490741 0 0.0183846209490741 1 0.018384693187037 1 0.018384693287037 0 0.0183850548768518 0 0.0183850549768519 1 0.0183851272148148 1 0.0183851273148148 0 0.0183857059185185 0 0.0183857060185185 1 0.0183857782564815 1 0.0183857783564815 0 0.0183872973537037 0 0.0183872974537037 1 0.0183873696916667 1 0.0183873697916667 0 0.0183878037194444 0 0.0183878038194444 1 0.0183878760574074 1 0.0183878761574074 0 0.018388599437037 0 0.018388599537037 1 0.018388671775 1 0.018388671875 0 0.0183895398305556 0 0.0183895399305556 1 0.0183896121685185 1 0.0183896122685185 0 0.0183896845064815 0 0.0183896846064815 1 0.0183897568444444 1 0.0183897569444444 0 0.018390697237963 0 0.018390697337963 1 0.0183907695759259 1 0.0183907696759259 0 0.0183909865898148 0 0.0183909866898148 1 0.0183910589277778 1 0.0183910590277778 0 0.0183912759416667 0 0.0183912760416667 1 0.0183913482796296 1 0.0183913483796296 0 0.0183916376314815 0 0.0183916377314815 1 0.0183917099694444 1 0.0183917100694444 0 0.0183922163351852 0 0.0183922164351852 1 0.0183922886731481 1 0.0183922887731481 0 0.0184376445759259 0 0.0184376446759259 1 0.0184377169138889 1 0.0184377170138889 0 0.0184378615898148 0 0.0184378616898148 1 0.0184379339277778 1 0.0184379340277778 0 0.0184381509416667 0 0.0184381510416667 1 0.0184382232796296 1 0.0184382233796296 0 0.0184385126314815 0 0.0184385127314815 1 0.0184385849694444 1 0.0184385850694444 0 0.0184387296453704 0 0.0184387297453704 1 0.0184388019833333 1 0.0184388020833333 0 0.0184390913351852 0 0.0184390914351852 1 0.0184391636731481 1 0.0184391637731481 0 0.0184393083490741 0 0.0184393084490741 1 0.018439380687037 1 0.018439380787037 0 0.0184396700388889 0 0.0184396701388889 1 0.0184397423768519 1 0.0184397424768519 0 0.0184401040666667 0 0.0184401041666667 1 0.0184401764046296 1 0.0184401765046296 0 0.018443431612963 0 0.018443431712963 1 0.0184435039509259 1 0.0184435040509259 0 0.0184442996685185 0 0.0184442997685185 1 0.0184443720064815 1 0.0184443721064815 0 0.0184445890203704 0 0.0184445891203704 1 0.0184446613583333 1 0.0184446614583333 0 0.0184450953861111 0 0.0184450954861111 1 0.0184451677240741 1 0.0184451678240741 0 0.0184454570759259 0 0.0184454571759259 1 0.0184455294138889 1 0.0184455295138889 0 0.0184460357796296 0 0.0184460358796296 1 0.0184461081175926 1 0.0184461082175926 0 0.0184463251314815 0 0.0184463252314815 1 0.0184463974694444 1 0.0184463975694444 0 0.0184468314972222 0 0.0184468315972222 1 0.0184469038351852 1 0.0184469039351852 0 0.0184471208490741 0 0.0184471209490741 1 0.018447193187037 1 0.018447193287037 0 0.0184475548768518 0 0.0184475549768519 1 0.0184476272148148 1 0.0184476273148148 0 0.0184482059185185 0 0.0184482060185185 1 0.0184482782564815 1 0.0184482783564815 0 0.0184497973537037 0 0.0184497974537037 1 0.0184498696916667 1 0.0184498697916667 0 0.0184503037194444 0 0.0184503038194444 1 0.0184503760574074 1 0.0184503761574074 0 0.018451099437037 0 0.018451099537037 1 0.018451171775 1 0.018451171875 0 0.0184520398305556 0 0.0184520399305556 1 0.0184521121685185 1 0.0184521122685185 0 0.0184522568444444 0 0.0184522569444444 1 0.0184523291824074 1 0.0184523292824074 0 0.018453197237963 0 0.018453197337963 1 0.0184532695759259 1 0.0184532696759259 0 0.0184535589277778 0 0.0184535590277778 1 0.0184536312657407 1 0.0184536313657407 0 0.0184537759416667 0 0.0184537760416667 1 0.0184538482796296 1 0.0184538483796296 0 0.0184539206175926 0 0.0184539207175926 1 0.0184540652935185 1 0.0184540653935185 0 0.0184541376314815 0 0.0184541377314815 1 0.0184542099694444 1 0.0184542100694444 0 0.0184547163351852 0 0.0184547164351852 1 0.0184547886731481 1 0.0184547887731481 0 0.0185001445759259 0 0.0185001446759259 1 0.0185002169138889 1 0.0185002170138889 0 0.0185003615898148 0 0.0185003616898148 1 0.0185004339277778 1 0.0185004340277778 0 0.0185006509416667 0 0.0185006510416667 1 0.0185007232796296 1 0.0185007233796296 0 0.0185010126314815 0 0.0185010127314815 1 0.0185010849694444 1 0.0185010850694444 0 0.0185012296453704 0 0.0185012297453704 1 0.0185013019833333 1 0.0185013020833333 0 0.0185015913351852 0 0.0185015914351852 1 0.0185016636731481 1 0.0185016637731481 0 0.0185018083490741 0 0.0185018084490741 1 0.018501880687037 1 0.018501880787037 0 0.0185021700388889 0 0.0185021701388889 1 0.0185022423768519 1 0.0185022424768519 0 0.0185026040666667 0 0.0185026041666667 1 0.0185026764046296 1 0.0185026765046296 0 0.018505859275 0 0.018505859375 1 0.018505931612963 1 0.018505931712963 0 0.0185067273305556 0 0.0185067274305556 1 0.0185067996685185 1 0.0185067997685185 0 0.0185070166824074 0 0.0185070167824074 1 0.0185070890203704 1 0.0185070891203704 0 0.0185075953861111 0 0.0185075954861111 1 0.0185076677240741 1 0.0185076678240741 0 0.0185079570759259 0 0.0185079571759259 1 0.0185080294138889 1 0.0185080295138889 0 0.0185084634416667 0 0.0185084635416667 1 0.0185085357796296 1 0.0185085358796296 0 0.0185087527935185 0 0.0185087528935185 1 0.0185088251314815 1 0.0185088252314815 0 0.0185093314972222 0 0.0185093315972222 1 0.0185094038351852 1 0.0185094039351852 0 0.0185096208490741 0 0.0185096209490741 1 0.018509693187037 1 0.018509693287037 0 0.0185100548768518 0 0.0185100549768519 1 0.0185101272148148 1 0.0185101273148148 0 0.0185106335805556 0 0.0185106336805556 1 0.0185107059185185 1 0.0185107060185185 0 0.0185123696916667 0 0.0185123697916667 1 0.0185124420296296 1 0.0185124421296296 0 0.0185128760574074 0 0.0185128761574074 1 0.0185129483953704 1 0.0185129484953704 0 0.0185131654092593 0 0.0185131655092593 1 0.0185132377472222 1 0.0185132378472222 0 0.0185135270990741 0 0.0185135271990741 1 0.018513599437037 1 0.018513599537037 0 0.0185145398305556 0 0.0185145399305556 1 0.0185146121685185 1 0.0185146122685185 0 0.0185148291824074 0 0.0185148292824074 1 0.0185149015203704 1 0.0185149016203704 0 0.018515697237963 0 0.018515697337963 1 0.0185157695759259 1 0.0185157696759259 0 0.0185159865898148 0 0.0185159866898148 1 0.0185160589277778 1 0.0185160590277778 0 0.0185162759416667 0 0.0185162760416667 1 0.0185163482796296 1 0.0185163483796296 0 0.0185164206175926 0 0.0185164207175926 1 0.0185165652935185 1 0.0185165653935185 0 0.0185166376314815 0 0.0185166377314815 1 0.0185167099694444 1 0.0185167100694444 0 0.0185168546453704 0 0.0185168547453704 1 0.0185169269833333 1 0.0185169270833333 0 0.0185172163351852 0 0.0185172164351852 1 0.0185172886731481 1 0.0185172887731481 0 0.0185627169138889 0 0.0185627170138889 1 0.0185628615898148 1 0.0185628616898148 0 0.0185632232796296 0 0.0185632233796296 1 0.0185635126314815 1 0.0185635127314815 0 0.0185638019833333 0 0.0185638020833333 1 0.0185640913351852 1 0.0185640914351852 0 0.018564380687037 0 0.018564380787037 1 0.0185646700388889 1 0.0185646701388889 0 0.0185651040666667 0 0.0185651041666667 1 0.0185651764046296 1 0.0185651765046296 0 0.018568359275 0 0.018568359375 1 0.0185687933027778 1 0.0185687934027778 0 0.0185689379787037 0 0.0185689380787037 1 0.0185692273305556 1 0.0185692274305556 0 0.0185701677240741 0 0.0185701678240741 1 0.0185704570759259 1 0.0185704571759259 0 0.0185706740898148 0 0.0185706741898148 1 0.0185709634416667 1 0.0185709635416667 0 0.0185719038351852 0 0.0185719039351852 1 0.0185721208490741 1 0.0185721209490741 0 0.0185725548768518 0 0.0185725549768519 1 0.0185726272148148 1 0.0185726273148148 0 0.0185730612425926 0 0.0185730613425926 1 0.0185731335805556 1 0.0185731336805556 0 0.0185749420296296 0 0.0185749421296296 1 0.0185750143675926 1 0.0185750144675926 0 0.0185754483953704 0 0.0185754484953704 1 0.0185756654092593 1 0.0185756655092593 0 0.0185759547611111 0 0.0185759548611111 1 0.0185760270990741 1 0.0185760271990741 0 0.0185770398305556 0 0.0185770399305556 1 0.0185771121685185 1 0.0185771122685185 0 0.0185774015203704 0 0.0185774016203704 1 0.0185774738583333 1 0.0185774739583333 0 0.018578197237963 0 0.018578197337963 1 0.0185784865898148 1 0.0185784866898148 0 0.0185788482796296 0 0.0185788483796296 1 0.0185789206175926 1 0.0185789207175926 0 0.0185790652935185 0 0.0185790653935185 1 0.0185791376314815 1 0.0185791377314815 0 0.0185794269833333 0 0.0185794270833333 1 0.0185797163351852 1 0.0185797164351852 0 0.0187499999 0 0.01875 1 0.0187505786037037 1 0.0187505787037037 0 0.0188124999 0 0.0188125 1 0.0188130786037037 1 0.0188130787037037 0 0.0188749999 0 0.018875 1 0.0188755786037037 1 0.0188755787037037 0 0.0189374999 0 0.0189375 1 0.0189380786037037 1 0.0189380787037037 0 0.0189999999 0 0.019 1 0.0190005786037037 1 0.0190005787037037 0 0.0190624999 0 0.0190625 1 0.0190630786037037 1 0.0190630787037037 0 0.0191249999 0 0.019125 1 0.0191255786037037 1 0.0191255787037037 0 0.0191874999 0 0.0191875 1 0.0191880786037037 1 0.0191880787037037 0 0.0192499999 0 0.01925 1 0.0192505786037037 1 0.0192505787037037 0 0.0193124999 0 0.0193125 1 0.0193130786037037 1 0.0193130787037037 0 0.0193749999 0 0.019375 1 0.0193755786037037 1 0.0193755787037037 0 0.0194374999 0 0.0194375 1 0.0194380786037037 1 0.0194380787037037 0 0.0195 0) r=0
Rwire_video_0 tx_video cable_video_0 0.075
Cwire_video_0 cable_video_0 0 3.75e-11
Rwire_video_1 cable_video_0 cable_video_1 0.075
Cwire_video_1 cable_video_1 0 3.75e-11
Rwire_video_2 cable_video_1 cable_video_2 0.075
Cwire_video_2 cable_video_2 0 3.75e-11
Rwire_video_3 cable_video_2 rx_video 0.075
Cwire_video_3 rx_video 0 3.75e-11
Vlogic_bsyn logic_bsyn computer_return PWL(0 0 4.62961962962963e-05 0 4.62962962962963e-05 1 5.21945225071225e-05 1 5.21946225071225e-05 0 0.000108796196296296 0 0.000108796296296296 1 0.000114694522507123 1 0.000114694622507123 0 0.000171296196296296 0 0.000171296296296296 1 0.000177194522507122 1 0.000177194622507122 0 0.000233796196296296 0 0.000233796296296296 1 0.000239694522507122 1 0.000239694622507122 0 0.000245592848717949 0 0.000245592948717949 1 0.000302194522507123 1 0.000302194622507122 0 0.000308092848717949 0 0.000308092948717949 1 0.000364694522507123 1 0.000364694622507122 0 0.000370592848717949 0 0.000370592948717949 1 0.000427194522507123 1 0.000427194622507122 0 0.000433092848717949 0 0.000433092948717949 1 0.000489694522507122 1 0.000489694622507123 0 0.000495592848717949 0 0.000495592948717949 1 0.000552194522507123 1 0.000552194622507123 0 0.000558092848717949 0 0.000558092948717949 1 0.000614694522507122 1 0.000614694622507123 0 0.000620592848717949 0 0.000620592948717949 1 0.000677194522507123 1 0.000677194622507123 0 0.000683092848717949 0 0.000683092948717949 1 0.000739694522507122 1 0.000739694622507123 0 0.000745592848717949 0 0.000745592948717949 1 0.000802194522507122 1 0.000802194622507122 0 0.000808092848717949 0 0.000808092948717949 1 0.000864694522507122 1 0.000864694622507123 0 0.000870592848717949 0 0.000870592948717949 1 0.000927194522507122 1 0.000927194622507122 0 0.000933092848717949 0 0.000933092948717949 1 0.000989694522507122 1 0.000989694622507122 0 0.000995592848717949 0 0.000995592948717949 1 0.00105219452250712 1 0.00105219462250712 0 0.00105809284871795 0 0.00105809294871795 1 0.00111469452250712 1 0.00111469462250712 0 0.00112059284871795 0 0.00112059294871795 1 0.00117719452250712 1 0.00117719462250712 0 0.00118309284871795 0 0.00118309294871795 1 0.00123969452250712 1 0.00123969462250712 0 0.00124559284871795 0 0.00124559294871795 1 0.00130219452250712 1 0.00130219462250712 0 0.00130809284871795 0 0.00130809294871795 1 0.00136469452250712 1 0.00136469462250712 0 0.00137059284871795 0 0.00137059294871795 1 0.00142719452250712 1 0.00142719462250712 0 0.00143309284871795 0 0.00143309294871795 1 0.00148969452250712 1 0.00148969462250712 0 0.00149559284871795 0 0.00149559294871795 1 0.00155219452250712 1 0.00155219462250712 0 0.00155809284871795 0 0.00155809294871795 1 0.00161469452250712 1 0.00161469462250712 0 0.00162059284871795 0 0.00162059294871795 1 0.00167719452250712 1 0.00167719462250712 0 0.00168309284871795 0 0.00168309294871795 1 0.00173969452250712 1 0.00173969462250712 0 0.00174559284871795 0 0.00174559294871795 1 0.00180219452250712 1 0.00180219462250712 0 0.00180809284871795 0 0.00180809294871795 1 0.00186469452250712 1 0.00186469462250712 0 0.00187059284871795 0 0.00187059294871795 1 0.00192719452250712 1 0.00192719462250712 0 0.00193309284871795 0 0.00193309294871795 1 0.00198969452250712 1 0.00198969462250712 0 0.00199559284871795 0 0.00199559294871795 1 0.00205219452250712 1 0.00205219462250712 0 0.00205809284871795 0 0.00205809294871795 1 0.00211469452250712 1 0.00211469462250712 0 0.00212059284871795 0 0.00212059294871795 1 0.00217719452250712 1 0.00217719462250712 0 0.00218309284871795 0 0.00218309294871795 1 0.00223969452250712 1 0.00223969462250712 0 0.00224559284871795 0 0.00224559294871795 1 0.00230219452250712 1 0.00230219462250712 0 0.00230809284871795 0 0.00230809294871795 1 0.00236469452250712 1 0.00236469462250712 0 0.00237059284871795 0 0.00237059294871795 1 0.00242719452250712 1 0.00242719462250712 0 0.00243309284871795 0 0.00243309294871795 1 0.00248969452250712 1 0.00248969462250712 0 0.00249559284871795 0 0.00249559294871795 1 0.00255219452250712 1 0.00255219462250712 0 0.00255809284871795 0 0.00255809294871795 1 0.00261469452250712 1 0.00261469462250712 0 0.00262059284871795 0 0.00262059294871795 1 0.00267719452250712 1 0.00267719462250712 0 0.00268309284871795 0 0.00268309294871795 1 0.00273969452250712 1 0.00273969462250712 0 0.00274559284871795 0 0.00274559294871795 1 0.00280219452250712 1 0.00280219462250712 0 0.00280809284871795 0 0.00280809294871795 1 0.00286469452250712 1 0.00286469462250712 0 0.00287059284871795 0 0.00287059294871795 1 0.00292719452250712 1 0.00292719462250712 0 0.00293309284871795 0 0.00293309294871795 1 0.00298969452250712 1 0.00298969462250712 0 0.00299559284871795 0 0.00299559294871795 1 0.00305219452250712 1 0.00305219462250712 0 0.00305809284871795 0 0.00305809294871795 1 0.00311469452250712 1 0.00311469462250712 0 0.00312059284871795 0 0.00312059294871795 1 0.00317719452250712 1 0.00317719462250712 0 0.00318309284871795 0 0.00318309294871795 1 0.00323969452250712 1 0.00323969462250712 0 0.00324559284871795 0 0.00324559294871795 1 0.00330219452250712 1 0.00330219462250712 0 0.00330809284871795 0 0.00330809294871795 1 0.00336469452250712 1 0.00336469462250712 0 0.00337059284871795 0 0.00337059294871795 1 0.00342719452250712 1 0.00342719462250712 0 0.00343309284871795 0 0.00343309294871795 1 0.00348969452250712 1 0.00348969462250712 0 0.00349559284871795 0 0.00349559294871795 1 0.00355219452250712 1 0.00355219462250712 0 0.00355809284871795 0 0.00355809294871795 1 0.00361469452250712 1 0.00361469462250712 0 0.00362059284871795 0 0.00362059294871795 1 0.00367719452250712 1 0.00367719462250712 0 0.00368309284871795 0 0.00368309294871795 1 0.00373969452250712 1 0.00373969462250712 0 0.00374559284871795 0 0.00374559294871795 1 0.00380219452250712 1 0.00380219462250712 0 0.00380809284871795 0 0.00380809294871795 1 0.00386469452250712 1 0.00386469462250712 0 0.00387059284871795 0 0.00387059294871795 1 0.00392719452250712 1 0.00392719462250712 0 0.00393309284871795 0 0.00393309294871795 1 0.00398969452250712 1 0.00398969462250712 0 0.00399559284871795 0 0.00399559294871795 1 0.00405219452250712 1 0.00405219462250712 0 0.00405809284871795 0 0.00405809294871795 1 0.00411469452250712 1 0.00411469462250712 0 0.00412059284871795 0 0.00412059294871795 1 0.00417719452250712 1 0.00417719462250712 0 0.00418309284871795 0 0.00418309294871795 1 0.00423969452250712 1 0.00423969462250712 0 0.00424559284871795 0 0.00424559294871795 1 0.00430219452250712 1 0.00430219462250712 0 0.00430809284871795 0 0.00430809294871795 1 0.00436469452250712 1 0.00436469462250712 0 0.00437059284871795 0 0.00437059294871795 1 0.00442719452250712 1 0.00442719462250712 0 0.00443309284871795 0 0.00443309294871795 1 0.00448969452250712 1 0.00448969462250712 0 0.00449559284871795 0 0.00449559294871795 1 0.00455219452250712 1 0.00455219462250712 0 0.00455809284871795 0 0.00455809294871795 1 0.00461469452250712 1 0.00461469462250712 0 0.00462059284871795 0 0.00462059294871795 1 0.00467719452250712 1 0.00467719462250712 0 0.00468309284871795 0 0.00468309294871795 1 0.00473969452250712 1 0.00473969462250712 0 0.00474559284871795 0 0.00474559294871795 1 0.00480219452250712 1 0.00480219462250712 0 0.00480809284871795 0 0.00480809294871795 1 0.00486469452250712 1 0.00486469462250712 0 0.00487059284871795 0 0.00487059294871795 1 0.00492719452250712 1 0.00492719462250712 0 0.00493309284871795 0 0.00493309294871795 1 0.00498969452250712 1 0.00498969462250712 0 0.00499559284871795 0 0.00499559294871795 1 0.00505219452250712 1 0.00505219462250712 0 0.00505809284871795 0 0.00505809294871795 1 0.00511469452250712 1 0.00511469462250712 0 0.00512059284871795 0 0.00512059294871795 1 0.00517719452250712 1 0.00517719462250712 0 0.00518309284871795 0 0.00518309294871795 1 0.00523969452250712 1 0.00523969462250712 0 0.00524559284871795 0 0.00524559294871795 1 0.00530219452250712 1 0.00530219462250712 0 0.00530809284871795 0 0.00530809294871795 1 0.00536469452250712 1 0.00536469462250712 0 0.00537059284871795 0 0.00537059294871795 1 0.00542719452250712 1 0.00542719462250712 0 0.00543309284871795 0 0.00543309294871795 1 0.00548969452250712 1 0.00548969462250712 0 0.00549559284871795 0 0.00549559294871795 1 0.00555219452250712 1 0.00555219462250712 0 0.00555809284871795 0 0.00555809294871795 1 0.00561469452250712 1 0.00561469462250712 0 0.00562059284871795 0 0.00562059294871795 1 0.00567719452250712 1 0.00567719462250712 0 0.00568309284871795 0 0.00568309294871795 1 0.00573969452250712 1 0.00573969462250712 0 0.00574559284871795 0 0.00574559294871795 1 0.00580219452250712 1 0.00580219462250712 0 0.00580809284871795 0 0.00580809294871795 1 0.00586469452250712 1 0.00586469462250712 0 0.00587059284871795 0 0.00587059294871795 1 0.00592719452250712 1 0.00592719462250712 0 0.00593309284871795 0 0.00593309294871795 1 0.00598969452250712 1 0.00598969462250712 0 0.00599559284871795 0 0.00599559294871795 1 0.00605219452250712 1 0.00605219462250712 0 0.00605809284871795 0 0.00605809294871795 1 0.00611469452250712 1 0.00611469462250712 0 0.00612059284871795 0 0.00612059294871795 1 0.00617719452250712 1 0.00617719462250712 0 0.00618309284871795 0 0.00618309294871795 1 0.00623969452250712 1 0.00623969462250712 0 0.00624559284871795 0 0.00624559294871795 1 0.00630219452250712 1 0.00630219462250712 0 0.00630809284871795 0 0.00630809294871795 1 0.00636469452250712 1 0.00636469462250712 0 0.00637059284871795 0 0.00637059294871795 1 0.00642719452250712 1 0.00642719462250712 0 0.00643309284871795 0 0.00643309294871795 1 0.00648969452250712 1 0.00648969462250712 0 0.00649559284871795 0 0.00649559294871795 1 0.00655219452250712 1 0.00655219462250712 0 0.00655809284871795 0 0.00655809294871795 1 0.00661469452250712 1 0.00661469462250712 0 0.00662059284871795 0 0.00662059294871795 1 0.00667719452250712 1 0.00667719462250712 0 0.00668309284871795 0 0.00668309294871795 1 0.00673969452250712 1 0.00673969462250712 0 0.00674559284871795 0 0.00674559294871795 1 0.00680219452250712 1 0.00680219462250712 0 0.00680809284871795 0 0.00680809294871795 1 0.00686469452250712 1 0.00686469462250712 0 0.00687059284871795 0 0.00687059294871795 1 0.00692719452250712 1 0.00692719462250712 0 0.00693309284871795 0 0.00693309294871795 1 0.00698969452250712 1 0.00698969462250712 0 0.00699559284871795 0 0.00699559294871795 1 0.00705219452250712 1 0.00705219462250712 0 0.00705809284871795 0 0.00705809294871795 1 0.00711469452250712 1 0.00711469462250712 0 0.00712059284871795 0 0.00712059294871795 1 0.00717719452250712 1 0.00717719462250712 0 0.00718309284871795 0 0.00718309294871795 1 0.00723969452250712 1 0.00723969462250712 0 0.00724559284871795 0 0.00724559294871795 1 0.00730219452250712 1 0.00730219462250712 0 0.00730809284871795 0 0.00730809294871795 1 0.00736469452250712 1 0.00736469462250712 0 0.00737059284871795 0 0.00737059294871795 1 0.00742719452250712 1 0.00742719462250712 0 0.00743309284871795 0 0.00743309294871795 1 0.00748969452250712 1 0.00748969462250712 0 0.00749559284871795 0 0.00749559294871795 1 0.00755219452250712 1 0.00755219462250712 0 0.00755809284871795 0 0.00755809294871795 1 0.00761469452250712 1 0.00761469462250712 0 0.00762059284871795 0 0.00762059294871795 1 0.00767719452250712 1 0.00767719462250712 0 0.00768309284871795 0 0.00768309294871795 1 0.00773969452250712 1 0.00773969462250712 0 0.00774559284871795 0 0.00774559294871795 1 0.00780219452250712 1 0.00780219462250712 0 0.00780809284871795 0 0.00780809294871795 1 0.00786469452250712 1 0.00786469462250712 0 0.00787059284871795 0 0.00787059294871795 1 0.00792719452250712 1 0.00792719462250712 0 0.00793309284871795 0 0.00793309294871795 1 0.00798969452250712 1 0.00798969462250712 0 0.00799559284871795 0 0.00799559294871795 1 0.00805219452250712 1 0.00805219462250712 0 0.00805809284871795 0 0.00805809294871795 1 0.00811469452250712 1 0.00811469462250712 0 0.00812059284871795 0 0.00812059294871795 1 0.00817719452250712 1 0.00817719462250712 0 0.00818309284871795 0 0.00818309294871795 1 0.00823969452250712 1 0.00823969462250712 0 0.00824559284871795 0 0.00824559294871795 1 0.00830219452250712 1 0.00830219462250712 0 0.00830809284871795 0 0.00830809294871795 1 0.00836469452250712 1 0.00836469462250712 0 0.00837059284871795 0 0.00837059294871795 1 0.00842719452250712 1 0.00842719462250712 0 0.00843309284871795 0 0.00843309294871795 1 0.00848969452250712 1 0.00848969462250712 0 0.00849559284871795 0 0.00849559294871795 1 0.00855219452250712 1 0.00855219462250712 0 0.00855809284871795 0 0.00855809294871795 1 0.00861469452250712 1 0.00861469462250712 0 0.00862059284871795 0 0.00862059294871795 1 0.00867719452250712 1 0.00867719462250712 0 0.00868309284871795 0 0.00868309294871795 1 0.00873969452250712 1 0.00873969462250712 0 0.00874559284871795 0 0.00874559294871795 1 0.00880219452250712 1 0.00880219462250712 0 0.00880809284871795 0 0.00880809294871795 1 0.00886469452250712 1 0.00886469462250712 0 0.00887059284871795 0 0.00887059294871795 1 0.00892719452250712 1 0.00892719462250712 0 0.00893309284871795 0 0.00893309294871795 1 0.00898969452250712 1 0.00898969462250712 0 0.00899559284871795 0 0.00899559294871795 1 0.00905219452250712 1 0.00905219462250712 0 0.00905809284871795 0 0.00905809294871795 1 0.00911469452250712 1 0.00911469462250712 0 0.00912059284871795 0 0.00912059294871795 1 0.00917719452250712 1 0.00917719462250712 0 0.00918309284871795 0 0.00918309294871795 1 0.00923969452250712 1 0.00923969462250712 0 0.00924559284871795 0 0.00924559294871795 1 0.00930219452250712 1 0.00930219462250712 0 0.00930809284871795 0 0.00930809294871795 1 0.00936469452250712 1 0.00936469462250712 0 0.00937059284871795 0 0.00937059294871795 1 0.00942719452250712 1 0.00942719462250712 0 0.00943309284871795 0 0.00943309294871795 1 0.00948969452250712 1 0.00948969462250712 0 0.00949559284871795 0 0.00949559294871795 1 0.00955219452250712 1 0.00955219462250712 0 0.00955809284871795 0 0.00955809294871795 1 0.00961469452250712 1 0.00961469462250712 0 0.00962059284871795 0 0.00962059294871795 1 0.00967719452250712 1 0.00967719462250712 0 0.00968309284871795 0 0.00968309294871795 1 0.00973969452250712 1 0.00973969462250712 0 0.00974559284871795 0 0.00974559294871795 1 0.00980219452250712 1 0.00980219462250712 0 0.00980809284871795 0 0.00980809294871795 1 0.00986469452250712 1 0.00986469462250712 0 0.00987059284871795 0 0.00987059294871795 1 0.00992719452250712 1 0.00992719462250712 0 0.00993309284871795 0 0.00993309294871795 1 0.00998969452250712 1 0.00998969462250712 0 0.00999559284871795 0 0.00999559294871795 1 0.0100521945225071 1 0.0100521946225071 0 0.0100580928487179 0 0.0100580929487179 1 0.0101146945225071 1 0.0101146946225071 0 0.0101205928487179 0 0.0101205929487179 1 0.0101771945225071 1 0.0101771946225071 0 0.0101830928487179 0 0.0101830929487179 1 0.0102396945225071 1 0.0102396946225071 0 0.0102455928487179 0 0.0102455929487179 1 0.0103021945225071 1 0.0103021946225071 0 0.0103080928487179 0 0.0103080929487179 1 0.0103646945225071 1 0.0103646946225071 0 0.0103705928487179 0 0.0103705929487179 1 0.0104271945225071 1 0.0104271946225071 0 0.0104330928487179 0 0.0104330929487179 1 0.0104896945225071 1 0.0104896946225071 0 0.0104955928487179 0 0.0104955929487179 1 0.0105521945225071 1 0.0105521946225071 0 0.0105580928487179 0 0.0105580929487179 1 0.0106146945225071 1 0.0106146946225071 0 0.0106205928487179 0 0.0106205929487179 1 0.0106771945225071 1 0.0106771946225071 0 0.0106830928487179 0 0.0106830929487179 1 0.0107396945225071 1 0.0107396946225071 0 0.0107455928487179 0 0.0107455929487179 1 0.0108021945225071 1 0.0108021946225071 0 0.0108080928487179 0 0.0108080929487179 1 0.0108646945225071 1 0.0108646946225071 0 0.0108705928487179 0 0.0108705929487179 1 0.0109271945225071 1 0.0109271946225071 0 0.0109330928487179 0 0.0109330929487179 1 0.0109896945225071 1 0.0109896946225071 0 0.0109955928487179 0 0.0109955929487179 1 0.0110521945225071 1 0.0110521946225071 0 0.0110580928487179 0 0.0110580929487179 1 0.0111146945225071 1 0.0111146946225071 0 0.0111205928487179 0 0.0111205929487179 1 0.0111771945225071 1 0.0111771946225071 0 0.0111830928487179 0 0.0111830929487179 1 0.0112396945225071 1 0.0112396946225071 0 0.0112455928487179 0 0.0112455929487179 1 0.0113021945225071 1 0.0113021946225071 0 0.0113080928487179 0 0.0113080929487179 1 0.0113646945225071 1 0.0113646946225071 0 0.0113705928487179 0 0.0113705929487179 1 0.0114271945225071 1 0.0114271946225071 0 0.0114330928487179 0 0.0114330929487179 1 0.0114896945225071 1 0.0114896946225071 0 0.0114955928487179 0 0.0114955929487179 1 0.0115521945225071 1 0.0115521946225071 0 0.0115580928487179 0 0.0115580929487179 1 0.0116146945225071 1 0.0116146946225071 0 0.0116205928487179 0 0.0116205929487179 1 0.0116771945225071 1 0.0116771946225071 0 0.0116830928487179 0 0.0116830929487179 1 0.0117396945225071 1 0.0117396946225071 0 0.0117455928487179 0 0.0117455929487179 1 0.0118021945225071 1 0.0118021946225071 0 0.0118080928487179 0 0.0118080929487179 1 0.0118646945225071 1 0.0118646946225071 0 0.0118705928487179 0 0.0118705929487179 1 0.0119271945225071 1 0.0119271946225071 0 0.0119330928487179 0 0.0119330929487179 1 0.0119896945225071 1 0.0119896946225071 0 0.0119955928487179 0 0.0119955929487179 1 0.0120521945225071 1 0.0120521946225071 0 0.0120580928487179 0 0.0120580929487179 1 0.0121146945225071 1 0.0121146946225071 0 0.0121205928487179 0 0.0121205929487179 1 0.0121771945225071 1 0.0121771946225071 0 0.0121830928487179 0 0.0121830929487179 1 0.0122396945225071 1 0.0122396946225071 0 0.0122455928487179 0 0.0122455929487179 1 0.0123021945225071 1 0.0123021946225071 0 0.0123080928487179 0 0.0123080929487179 1 0.0123646945225071 1 0.0123646946225071 0 0.0123705928487179 0 0.0123705929487179 1 0.0124271945225071 1 0.0124271946225071 0 0.0124330928487179 0 0.0124330929487179 1 0.0124896945225071 1 0.0124896946225071 0 0.0124955928487179 0 0.0124955929487179 1 0.0125521945225071 1 0.0125521946225071 0 0.0125580928487179 0 0.0125580929487179 1 0.0126146945225071 1 0.0126146946225071 0 0.0126205928487179 0 0.0126205929487179 1 0.0126771945225071 1 0.0126771946225071 0 0.0126830928487179 0 0.0126830929487179 1 0.0127396945225071 1 0.0127396946225071 0 0.0127455928487179 0 0.0127455929487179 1 0.0128021945225071 1 0.0128021946225071 0 0.0128080928487179 0 0.0128080929487179 1 0.0128646945225071 1 0.0128646946225071 0 0.0128705928487179 0 0.0128705929487179 1 0.0129271945225071 1 0.0129271946225071 0 0.0129330928487179 0 0.0129330929487179 1 0.0129896945225071 1 0.0129896946225071 0 0.0129955928487179 0 0.0129955929487179 1 0.0130521945225071 1 0.0130521946225071 0 0.0130580928487179 0 0.0130580929487179 1 0.0131146945225071 1 0.0131146946225071 0 0.0131205928487179 0 0.0131205929487179 1 0.0131771945225071 1 0.0131771946225071 0 0.0131830928487179 0 0.0131830929487179 1 0.0132396945225071 1 0.0132396946225071 0 0.0132455928487179 0 0.0132455929487179 1 0.0133021945225071 1 0.0133021946225071 0 0.0133080928487179 0 0.0133080929487179 1 0.0133646945225071 1 0.0133646946225071 0 0.0133705928487179 0 0.0133705929487179 1 0.0134271945225071 1 0.0134271946225071 0 0.0134330928487179 0 0.0134330929487179 1 0.0134896945225071 1 0.0134896946225071 0 0.0134955928487179 0 0.0134955929487179 1 0.0135521945225071 1 0.0135521946225071 0 0.0135580928487179 0 0.0135580929487179 1 0.0136146945225071 1 0.0136146946225071 0 0.0136205928487179 0 0.0136205929487179 1 0.0136771945225071 1 0.0136771946225071 0 0.0136830928487179 0 0.0136830929487179 1 0.0137396945225071 1 0.0137396946225071 0 0.0137455928487179 0 0.0137455929487179 1 0.0138021945225071 1 0.0138021946225071 0 0.0138080928487179 0 0.0138080929487179 1 0.0138646945225071 1 0.0138646946225071 0 0.0138705928487179 0 0.0138705929487179 1 0.0139271945225071 1 0.0139271946225071 0 0.0139330928487179 0 0.0139330929487179 1 0.0139896945225071 1 0.0139896946225071 0 0.0139955928487179 0 0.0139955929487179 1 0.0140521945225071 1 0.0140521946225071 0 0.0140580928487179 0 0.0140580929487179 1 0.0141146945225071 1 0.0141146946225071 0 0.0141205928487179 0 0.0141205929487179 1 0.0141771945225071 1 0.0141771946225071 0 0.0141830928487179 0 0.0141830929487179 1 0.0142396945225071 1 0.0142396946225071 0 0.0142455928487179 0 0.0142455929487179 1 0.0143021945225071 1 0.0143021946225071 0 0.0143080928487179 0 0.0143080929487179 1 0.0143646945225071 1 0.0143646946225071 0 0.0143705928487179 0 0.0143705929487179 1 0.0144271945225071 1 0.0144271946225071 0 0.0144330928487179 0 0.0144330929487179 1 0.0144896945225071 1 0.0144896946225071 0 0.0144955928487179 0 0.0144955929487179 1 0.0145521945225071 1 0.0145521946225071 0 0.0145580928487179 0 0.0145580929487179 1 0.0146146945225071 1 0.0146146946225071 0 0.0146205928487179 0 0.0146205929487179 1 0.0146771945225071 1 0.0146771946225071 0 0.0146830928487179 0 0.0146830929487179 1 0.0147396945225071 1 0.0147396946225071 0 0.0147455928487179 0 0.0147455929487179 1 0.0148021945225071 1 0.0148021946225071 0 0.0148080928487179 0 0.0148080929487179 1 0.0148646945225071 1 0.0148646946225071 0 0.0148705928487179 0 0.0148705929487179 1 0.0149271945225071 1 0.0149271946225071 0 0.0149330928487179 0 0.0149330929487179 1 0.0149896945225071 1 0.0149896946225071 0 0.0149955928487179 0 0.0149955929487179 1 0.0150521945225071 1 0.0150521946225071 0 0.0150580928487179 0 0.0150580929487179 1 0.0151146945225071 1 0.0151146946225071 0 0.0151205928487179 0 0.0151205929487179 1 0.0151771945225071 1 0.0151771946225071 0 0.0151830928487179 0 0.0151830929487179 1 0.0152396945225071 1 0.0152396946225071 0 0.0152455928487179 0 0.0152455929487179 1 0.0153021945225071 1 0.0153021946225071 0 0.0153080928487179 0 0.0153080929487179 1 0.0153646945225071 1 0.0153646946225071 0 0.0153705928487179 0 0.0153705929487179 1 0.0154271945225071 1 0.0154271946225071 0 0.0154330928487179 0 0.0154330929487179 1 0.0154896945225071 1 0.0154896946225071 0 0.0154955928487179 0 0.0154955929487179 1 0.0155521945225071 1 0.0155521946225071 0 0.0155580928487179 0 0.0155580929487179 1 0.0156146945225071 1 0.0156146946225071 0 0.0156205928487179 0 0.0156205929487179 1 0.0156771945225071 1 0.0156771946225071 0 0.0156830928487179 0 0.0156830929487179 1 0.0157396945225071 1 0.0157396946225071 0 0.0157455928487179 0 0.0157455929487179 1 0.0158021945225071 1 0.0158021946225071 0 0.0158080928487179 0 0.0158080929487179 1 0.0158646945225071 1 0.0158646946225071 0 0.0158705928487179 0 0.0158705929487179 1 0.0159271945225071 1 0.0159271946225071 0 0.0159330928487179 0 0.0159330929487179 1 0.0159896945225071 1 0.0159896946225071 0 0.0159955928487179 0 0.0159955929487179 1 0.0160521945225071 1 0.0160521946225071 0 0.0160580928487179 0 0.0160580929487179 1 0.0161146945225071 1 0.0161146946225071 0 0.0161205928487179 0 0.0161205929487179 1 0.0161771945225071 1 0.0161771946225071 0 0.0161830928487179 0 0.0161830929487179 1 0.0162396945225071 1 0.0162396946225071 0 0.0162455928487179 0 0.0162455929487179 1 0.0163021945225071 1 0.0163021946225071 0 0.0163080928487179 0 0.0163080929487179 1 0.0163646945225071 1 0.0163646946225071 0 0.0163705928487179 0 0.0163705929487179 1 0.0164271945225071 1 0.0164271946225071 0 0.0164330928487179 0 0.0164330929487179 1 0.0164896945225071 1 0.0164896946225071 0 0.0164955928487179 0 0.0164955929487179 1 0.0165521945225071 1 0.0165521946225071 0 0.0165580928487179 0 0.0165580929487179 1 0.0166146945225071 1 0.0166146946225071 0 0.0166205928487179 0 0.0166205929487179 1 0.0166771945225071 1 0.0166771946225071 0 0.0166830928487179 0 0.0166830929487179 1 0.0167396945225071 1 0.0167396946225071 0 0.0167455928487179 0 0.0167455929487179 1 0.0168021945225071 1 0.0168021946225071 0 0.0168080928487179 0 0.0168080929487179 1 0.0168646945225071 1 0.0168646946225071 0 0.0168705928487179 0 0.0168705929487179 1 0.0169271945225071 1 0.0169271946225071 0 0.0169330928487179 0 0.0169330929487179 1 0.0169896945225071 1 0.0169896946225071 0 0.0169955928487179 0 0.0169955929487179 1 0.0170521945225071 1 0.0170521946225071 0 0.0170580928487179 0 0.0170580929487179 1 0.0171146945225071 1 0.0171146946225071 0 0.0171205928487179 0 0.0171205929487179 1 0.0171771945225071 1 0.0171771946225071 0 0.0171830928487179 0 0.0171830929487179 1 0.0172396945225071 1 0.0172396946225071 0 0.0172455928487179 0 0.0172455929487179 1 0.0173021945225071 1 0.0173021946225071 0 0.0173080928487179 0 0.0173080929487179 1 0.0173646945225071 1 0.0173646946225071 0 0.0173705928487179 0 0.0173705929487179 1 0.0174271945225071 1 0.0174271946225071 0 0.0174330928487179 0 0.0174330929487179 1 0.0174896945225071 1 0.0174896946225071 0 0.0174955928487179 0 0.0174955929487179 1 0.0175521945225071 1 0.0175521946225071 0 0.0175580928487179 0 0.0175580929487179 1 0.0176146945225071 1 0.0176146946225071 0 0.0176205928487179 0 0.0176205929487179 1 0.0176771945225071 1 0.0176771946225071 0 0.0176830928487179 0 0.0176830929487179 1 0.0177396945225071 1 0.0177396946225071 0 0.0177455928487179 0 0.0177455929487179 1 0.0178021945225071 1 0.0178021946225071 0 0.0178080928487179 0 0.0178080929487179 1 0.0178646945225071 1 0.0178646946225071 0 0.0178705928487179 0 0.0178705929487179 1 0.0179271945225071 1 0.0179271946225071 0 0.0179330928487179 0 0.0179330929487179 1 0.0179896945225071 1 0.0179896946225071 0 0.0179955928487179 0 0.0179955929487179 1 0.0180521945225071 1 0.0180521946225071 0 0.0180580928487179 0 0.0180580929487179 1 0.0181146945225071 1 0.0181146946225071 0 0.0181205928487179 0 0.0181205929487179 1 0.0181771945225071 1 0.0181771946225071 0 0.0181830928487179 0 0.0181830929487179 1 0.0182396945225071 1 0.0182396946225071 0 0.0182455928487179 0 0.0182455929487179 1 0.0183021945225071 1 0.0183021946225071 0 0.0183080928487179 0 0.0183080929487179 1 0.0183646945225071 1 0.0183646946225071 0 0.0183705928487179 0 0.0183705929487179 1 0.0184271945225071 1 0.0184271946225071 0 0.0184330928487179 0 0.0184330929487179 1 0.0184896945225071 1 0.0184896946225071 0 0.0184955928487179 0 0.0184955929487179 1 0.0185521945225071 1 0.0185521946225071 0 0.0185580928487179 0 0.0185580929487179 1 0.0186146945225071 1 0.0186146946225071 0 0.0186205928487179 0 0.0186205929487179 1 0.0186771945225071 1 0.0186771946225071 0 0.0186830928487179 0 0.0186830929487179 1 0.0187396945225071 1 0.0187396946225071 0 0.0187455928487179 0 0.0187455929487179 1 0.0188021945225071 1 0.0188021946225071 0 0.0188080928487179 0 0.0188080929487179 1 0.0188646945225071 1 0.0188646946225071 0 0.0188705928487179 0 0.0188705929487179 1 0.0189271945225071 1 0.0189271946225071 0 0.0189330928487179 0 0.018933092948718 1 0.0189896945225071 1 0.0189896946225071 0 0.0189955928487179 0 0.018995592948718 1 0.0190521945225071 1 0.0190521946225071 0 0.0190580928487179 0 0.019058092948718 1 0.0191146945225071 1 0.0191146946225071 0 0.0191205928487179 0 0.019120592948718 1 0.0191771945225071 1 0.0191771946225071 0 0.0191830928487179 0 0.019183092948718 1 0.0192396945225071 1 0.0192396946225071 0 0.0192455928487179 0 0.019245592948718 1 0.0193021945225071 1 0.0193021946225071 0 0.0193080928487179 0 0.019308092948718 1 0.0193646945225071 1 0.0193646946225071 0 0.0193705928487179 0 0.019370592948718 1 0.0194271945225071 1 0.0194271946225071 0 0.0194330928487179 0 0.0194330929487179 1 0.0194896945225071 1 0.0194896946225071 0 0.0194955928487179 0 0.0194955929487179 1 0.0194999999 1 0.0195 0) r=0
Rwire_bsyn_0 tx_bsyn cable_bsyn_0 0.075
Cwire_bsyn_0 cable_bsyn_0 0 3.75e-11
Rwire_bsyn_1 cable_bsyn_0 cable_bsyn_1 0.075
Cwire_bsyn_1 cable_bsyn_1 0 3.75e-11
Rwire_bsyn_2 cable_bsyn_1 cable_bsyn_2 0.075
Cwire_bsyn_2 cable_bsyn_2 0 3.75e-11
Rwire_bsyn_3 cable_bsyn_2 rx_bsyn 0.075
Cwire_bsyn_3 rx_bsyn 0 3.75e-11
Vlogic_intens logic_intens computer_return PWL(0 1 0.0195 1) r=0
Rwire_intens_0 tx_intens cable_intens_0 0.075
Cwire_intens_0 cable_intens_0 0 3.75e-11
Rwire_intens_1 cable_intens_0 cable_intens_1 0.075
Cwire_intens_1 cable_intens_1 0 3.75e-11
Rwire_intens_2 cable_intens_1 cable_intens_2 0.075
Cwire_intens_2 cable_intens_2 0 3.75e-11
Rwire_intens_3 cable_intens_2 rx_intens 0.075
Cwire_intens_3 rx_intens 0 3.75e-11
Rreturn computer_return 0 0.2
Vp12 p12 0 12
Vp22 p22 0 22
Vp41 p41 0 41
Vn16 n16 0 -16
Rcontrast_top contrast_adjust intens {contrast_r*contrast_position}
Rcontrast_bottom intens contrast_low {contrast_r*(1-contrast_position)}
Xcrt p10_7 0 cathode g1 g2 eht heater_rise cathode_rise CRT_THERMAL
Ctube eht 0 {tube_anode_c}
Rhvleak eht 0 {tube_hv_leakage}
Rhorizontal hy1 h_winding {yoke_horizontal_r}
Lhorizontal h_winding hy2 {yoke_horizontal_l}
Rvertical y1 v_winding {yoke_vertical_r}
Lvertical v_winding y2 {yoke_vertical_l}
Rcapmid h_rectmid 0 {isolated_cap_leakage}
Ryokeleak hy1 0 {isolated_cap_leakage}
.options klu reltol=0.005 abstol=1e-06 vntol=1e-6 method=gear
.save time v(eht) v(g2) v(g4) v(cathode) i(Lhorizontal) i(Lvertical) @b.xcrt.bbeam[i] v(p10_7) i(v.xcrt.vheater) v(h_hot) v(h_feedback) v(vertical_trigger) v(vertical_pulse) v(x1136.xshared.flux_b) v(p5) v(h_boost) v(g1) v(h_control) i(Vp41) v(sync_c) v(h_pd) v(h_tank) v(h_reactbase) @d1032[id] @d1033[id] v(xcrt.launch_current) v(xcrt.emitted_current) @b.xcrt.bg2[i]
.ic v(eht)=8000 v(h_boost)=60 v(h_divtop)=420 v(h_g1raw)=-20 v(h_g2raw)=420
.tran 2e-07 0.156 0.078 2e-07
.end
