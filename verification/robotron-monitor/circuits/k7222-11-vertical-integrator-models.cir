* Generic devices; historical connectivity does not establish device accuracy.
.model VERTICAL_NPN_BOUND NPN(IS=1e-14 BF={vertical_bf} VAF=60 CJE=20p CJC=8p TF=2n TR=20n)
* Separate printed SF127C group-C NPN; DDR SF126-129 sheet, not a fitted curve.
* Printed SF127C V18: explicit family-class terms, with group-C gain retained.
.model SF127C_N NPN(IS=1e-14 BF=90 VAF=60 RC=1 RE=0.25 CJE=20p CJC=8p TF=2n TR=20n IKF=0.5 RB=1 VJE=0.75 MJE=0.33 VJC=0.75 MJC=0.33 EG=1.11 XTI=3 FC=0.5)
.model 1AD50_BOUND D(IS=2n RS=2 N=1.7 CJO=2p TT=5n BV=100 IBV=100u VJ=1 M=0.5 FC=0.5 EG=1.11 XTI=3)
* Provisional 1AE15 signal/bias-diode class; 1N4148 is a comparator, not an identified original.
.model VERTICAL_DIODE D(IS=2n RS=2 N=1.7 CJO=2p TT=5n BV=100 IBV=100u VJ=1 M=0.5 FC=0.5 EG=1.11 XTI=3)
* KFY18-class PNP proxy: Tesla 1987 catalog, pages 221-223; not a fitted factory curve.
.model VERTICAL_PNP_BOUND PNP(IS=1e-14 BF={retrace_bf} VAF=60 RC=3 RE=0.25 CJE=65p CJC=45p TF=1.5n TR=50n EG=1.11 FC=0.5 IKF=0.3 MJC=0.33 MJE=0.33 RB=2 VJC=0.75 VJE=0.75 XTI=3)
* 723-family functional equivalent: TI SNVS765C p2 metal-can pin contract.
* cs inv noninv ref vminus out collector vplus compensation current-limit
* NOT a transistor-level Tesla MAA723 model. No thermal/SOA qualification.
* Error gm and drive bound by the uA723-class 1..50 mA output response;
* internal 30 pF pole and transistor curves remain unqualified assumptions.
.subckt MAA723_BOUND cs inv noninv ref vm out vc vp comp cl
Breference ref_i vm V={min(m723_ref_v,max(v(vp,vm)-2.35,0))}
Rreference ref_i ref 10
Breference_draw vp vm I={max(i(Breference)*-1,0)}
Bquiescent vp vm I={m723_iq*min(max(v(vp,vm)/9.5,0),1)}
Rinput inv noninv 10Meg
Bdrive_up vp comp I={max(min(m723_error_gm*v(noninv,inv),m723_drive_limit),0)*min(max(v(vp,vm)/9.5,0),1)}
Bdrive_down comp vm I={max(min(-m723_error_gm*v(noninv,inv),m723_drive_limit),0)*min(max(v(vp,vm)/9.5,0),1)}
Rgain comp vm 10Meg
Cinternal comp vm 30p
Dupper comp vp M723_CLAMP
Dlower vm comp M723_CLAMP
Qpass vc comp out M723_PASS
Qlimit comp cl cs M723_LIMIT
Rout out vm 1Meg
.model M723_PASS NPN(IS=1e-14 BF=100 VAF=60 CJE=30p CJC=10p TF=5n)
.model M723_LIMIT NPN(IS=1e-14 BF=100 VAF=60)
.model M723_CLAMP D(IS=1e-12 RS=10)
.ends MAA723_BOUND
