Vsupply external12 0 PWL(0 0 1m {input_voltage})
Rsource external12 input12 .1
* V2 is off: characterized free running; no horizontal circuit yet.
Vhorizontal horizontal_sync 0 0
Rload41 p41 0 {load41}
Rload22 p22 0 {load22}
Rload16 0 n16 {load16}
