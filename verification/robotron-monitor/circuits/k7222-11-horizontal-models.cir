* Bounded engineering families, NOT measured SC237E/SF1260/SF1280 curves.
.model HOR_D D(IS=1n N=1.5 RS=2 CJO=2p TT=5n BV=100 IBV=100u VJ=1 M=0.5 FC=0.5 EG=1.11 XTI=3)
.model SC237E_N NPN(IS=1e-14 BF=300 VAF=80 RC=1 RE=0.25 CJE=7.7p CJC=3.8p TF=0.9n TR=10n)
.model HOR_N NPN(IS=1e-14 BF=100 VAF=80 CJE=20p CJC=8p TF=2n TR=10n)
* SF128-family V13 candidate: explicit high-current and junction assumptions.
* SF1280 suffix and inductive storage/fall behavior remain unverified.
.model HOR_DRIVER_N NPN(IS=1e-12 BF=60 VAF=80 CJE=20p CJC=8p TF=1n TR=100n IKF=500m RB=1 RC=100m RE=50m VJE=0.75 MJE=0.33 VJC=0.75 MJC=0.33 EG=1.11 XTI=3 FC=0.5)
.subckt HORIZONTAL_TRIM top wiper bottom
Ra top wiper {1000*(1-horizontal_trim_fraction)}
Rb wiper bottom {1000*horizontal_trim_fraction}
.ends HORIZONTAL_TRIM
* Tapped, phase-inverting tank. Inductance is PER HALF winding.
.subckt HORIZONTAL_TANK left middle right
Ra left a {horizontal_tank_r}
Rb right b {horizontal_tank_r}
La a middle {horizontal_tank_l}
Lb middle b {horizontal_tank_l}
Kcore La Lb {horizontal_tank_coupling}
.ends HORIZONTAL_TANK
* Opposite polarity secondary for turn-off transformer drive.
.subckt HORIZONTAL_DRIVER top collector base ground
Rp top p {horizontal_driver_r}
Lp p collector {horizontal_driver_l}
Rs s base {horizontal_secondary_r}
Ls ground s {horizontal_driver_l/horizontal_driver_ratio^2}
Kcore Lp Ls {horizontal_driver_coupling}
.ends HORIZONTAL_DRIVER
* Output families and normal-operation ancillary components; no SOA claim.
.model HOR_Z6 D(IS=1n N=1.5 RS=2 BV=6.2 IBV=1m CJO=100p TT=100n VJ=1 M=0.5 FC=0.5 EG=1.11 XTI=3)
.model HOR_RECT D(IS=10n N=1.5 RS=.2 CJO=40p TT=20n BV=1000 IBV=10u VJ=1 M=0.5 FC=0.5 EG=1.11 XTI=3)
.model HOR_HV_RECT D(IS=1n N=2 RS=90 CJO=0.95p TT=100n BV=15k IBV=2u VJ=1 M=0.5 FC=0.5 EG=1.11 XTI=3)
* BU508AF-class V18 candidate: IKF and series resistances are bounded by the
* 0.1/4.5 A gain and 4.5 A saturation comparisons, not an original SU165 fit.
* The level-1 BJT still lacks reverse emitter-base breakdown and SOA physics.
.model HOR_OUTPUT_N NPN(IS=1e-10 BF=20 VAF=100 CJE=1n CJC=200p TF=100n TR=500n IKF=5 RB=0.05 RC=0.02 RE=0.01 VJE=0.75 MJE=0.33 VJC=0.75 MJC=0.33 EG=1.11 XTI=3 FC=0.5)
.subckt HORIZONTAL_CHOKE a b
Rloss a n {horizontal_choke_r}
Lcore n b {horizontal_choke_l}
.ends HORIZONTAL_CHOKE
.subckt HORIZONTAL_LINEARITY a b
Rloss a n {horizontal_linearity_r}
Lcore n b {horizontal_linearity_l}
.ends HORIZONTAL_LINEARITY
.subckt HORIZONTAL_COMPENSATION a b
Rloss a n {horizontal_compensation_r}
Lcore n b {horizontal_compensation_l}
.ends HORIZONTAL_COMPENSATION
.subckt HORIZONTAL_BRIGHTNESS low wiper high
Ra low wiper {1meg*horizontal_brightness_fraction}
Rb wiper high {1meg*(1-horizontal_brightness_fraction)}
.ends HORIZONTAL_BRIGHTNESS
.subckt HORIZONTAL_FOCUS high wiper low
Ra high wiper {1meg*(1-horizontal_focus_fraction)}
Rb wiper low {1meg*horizontal_focus_fraction}
.ends HORIZONTAL_FOCUS
