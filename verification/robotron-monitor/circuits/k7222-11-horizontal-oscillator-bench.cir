* Standalone, deliberately unsynchronized bench; no prescribed oscillator waveform.
V12 p12 0 12
V22 p22 0 22
Vsync sync_c 0 0
Vfeedback h_feedback 0 0
Rsecondary h_outputbase 0 1000
