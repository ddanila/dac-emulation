* Explicit external source and load; not complete converter or monitor.
Vsupply external12 0 PWL(0 0 1m {reg5_input})
Rsource external12 p12 .2
Iload p5 0 PWL(0 0 1m .02 100m .02 100.01m .08 200m .08 200.01m .02)
