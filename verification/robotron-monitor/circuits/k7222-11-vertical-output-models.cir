* Engineering bounds, not fitted factory transistor curves.
.model VERT_Z16 D(IS=1n N=1.5 RS=2 BV=16 IBV=1m CJO=40p TT=100n VJ=1 M=0.5 FC=0.5 EG=1.11 XTI=3)
.model VERT_POWER_N NPN(IS=1e-12 BF={output_bf} VAF=80 CJE=200p CJC=80p TF={output_n_tf} TR=200n)
.model VERT_POWER_P PNP(IS=1e-12 BF={output_bf} VAF=80 CJE=200p CJC=80p TF={output_p_tf} TR=200n)
* Source R58 remains one inventoried device; no duplicate source identities.
.subckt VERT_POT top wiper bottom
Ra top wiper {470*symmetry_fraction}
Rb wiper bottom {470*(1-symmetry_fraction)}
.ends VERT_POT
