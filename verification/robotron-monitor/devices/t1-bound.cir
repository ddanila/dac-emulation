* Hypothetical T1; generated by converter_magnetics.py. No factory numerical data.
.subckt T1_CORE w0p w0n w1p w1n w2p w2n w3p w3n
Rw0 w0p r0 0.08
Ll0 r0 l0 1e-06
Cw0 w0p w0n 1e-10
Rw1 w1p r1 0.12
Ll1 r1 l1 2e-06
Cw1 w1p w1n 1e-10
Rw2 w2p r2 0.08
Ll2 r2 l2 1e-06
Cw2 w2p w2n 1e-10
Rw3 w3p r3 0.2
Ll3 r3 l3 2e-06
Cw3 w3p w3n 1e-10
Ew1 l1 w1n l0 w0n 1
Fw1 l0 w0n Ew1 -1
Ew2 l2 w2n l0 w0n 0.7
Fw2 l0 w0n Ew2 -0.7
Ew3 l3 w3n l0 w0n 1.4
Fw3 l0 w0n Ew3 -1.4
Cflux flux_b 0 1 IC=0
Rflux flux_b 0 1e12
Bflux 0 flux_b I={625*v(l0,w0n)}
Bprimary l0 w0n I={(0.003)*(3636.36363636364*v(flux_b)+(234.604105571848)*(v(flux_b)+.5*(sqrt((v(flux_b)-0.165)^2+1e-10)-sqrt((v(flux_b)+0.165)^2+1e-10)))+(31129.0322580645)*(v(flux_b)+.5*(sqrt((v(flux_b)-0.32)^2+1e-10)-sqrt((v(flux_b)+0.32)^2+1e-10))))}
Rloss l0 w0n 5000
.ends T1_CORE
.subckt T1_BOUND p12 collector t8 t7 ground t5
Xcore p12 collector collector t8 p12 t7 ground t5 T1_CORE
.ends T1_BOUND
