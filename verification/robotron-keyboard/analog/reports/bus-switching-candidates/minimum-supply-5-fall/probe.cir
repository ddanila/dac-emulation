I8282 published switching-load screen
Vdrive drive 0 0
Rdrive drive out 22.5
Vload bias 0 2.0099999999999998
Rload bias out 78
Cload out 0 3e-10 IC=5
.options reltol=1e-8 abstol=1e-12
.control
tran 0.05n 200n 0 0.05n uic
meas tran edge_time TRIG v(out) VAL=2.0 FALL=1 TARG v(out) VAL=0.8 FALL=1
quit
.endc
.end
