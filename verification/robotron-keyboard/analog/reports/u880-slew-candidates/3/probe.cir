CPU finite internal drive-slew hypothesis
Vdrive drive 0 PWL(0 4.75 1e-08 0)
Rdrive drive out 222.22222222222223
Cload out 0 1e-10 IC=4.75
.options reltol=1e-8 abstol=1e-12
.control
tran 0.02n 1u 0 0.02n uic
meas tran edge_time WHEN v(out)=0.80000000000000004 FALL=1
quit
.endc
.end
