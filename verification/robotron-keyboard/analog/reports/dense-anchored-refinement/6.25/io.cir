S600 firmware I/O service fixture
Vhost n_CABLE_5V n_CABLE_GND PWL(0 0 1u 5)
Vfixture_crossing_grid fixture_crossing_grid 0 PWL(
+ 0n 0
+ 500.28025n 0
+ 1000.72025n 0
+ 1500.28025n 0
+ 2000.72025n 0
+ 2500.28025n 0
+ 3000.72025n 0
+ 3500.28025n 0
+ 4000.72025n 0
+ 4500.28025n 0
+ 5000.72025n 0
+ 5500.28025n 0
+ 6000.72025n 0
+ 6500.28025n 0
+ 7000.72025n 0
+ 7500.28025n 0
+ 8000.72025n 0
+ 8500.28025n 0
+ 9000.72025n 0
+ 9500.28025n 0
+ 10000.72025n 0
+ 10500.28025n 0
+ 11000.72025n 0
+ 11500.28025n 0
+ 12000.72025n 0
+ 12500.28025n 0
+ 13000.72025n 0
+ 13500.28025n 0
+ 14000.72025n 0
+ 14500.28025n 0
+ 15000.72025n 0
+ 15500.28025n 0
+ 16000.72025n 0
+ 16500.28025n 0
+ 17000.72025n 0
+ 17500.28025n 0
+ 18000.72025n 0
+ 18500.28025n 0
+ 19000.72025n 0
+ 19500.28025n 0
+ 20000.72025n 0
+ 20500.28025n 0
+ 21000.72025n 0
+ 21500.28025n 0
+ 22000.72025n 0
+ 22500.28025n 0
+ 23000.72025n 0
+ 23500.28025n 0
+ 24000.72025n 0
+ 24500.28025n 0
+ 25000.72025n 0
+ 25500.28025n 0
+ 26000.72025n 0
+ 26500.28025n 0
+ 27000.72025n 0
+ 27500.28025n 0
+ 28000.72025n 0
+ 28500.28025n 0
+ 29000.72025n 0
+ 29500.28025n 0
+ 30000.72025n 0
+ 30500.28025n 0
+ 31000.72025n 0
+ 31500.28025n 0
+ 32000.72025n 0
+ 32500.28025n 0
+ 33000.72025n 0
+ 33500.28025n 0
+ 34000.72025n 0
+ 34500.28025n 0
+ 35000.72025n 0
+ 35500.28025n 0
+ 36000.72025n 0
+ 36500.28025n 0
+ 37000.72025n 0
+ 37500.28025n 0
+ 38000.72025n 0
+ 38500.28025n 0
+ 39000.72025n 0
+ 39500.28025n 0
+ 40000.72025n 0
+ 40500.28025n 0
+ 41000.72025n 0
+ 41500.28025n 0
+ 42000.72025n 0
+ 42500.28025n 0
+ 43000.72025n 0
+ 43500.28025n 0
+ 44000.72025n 0
+ 44500.28025n 0
+ 45000.72025n 0
+ 45500.28025n 0
+ 46000.72025n 0
+ 46500.28025n 0
+ 47000.72025n 0
+ 47500.28025n 0
+ 48000.72025n 0
+ 48500.28025n 0
+ 49000.72025n 0
+ 49500.28025n 0
+ 50000.72025n 0
+ 50500.28025n 0
+ 51000.72025n 0
+ 51500.28025n 0
+ 52000.72025n 0
+ 52500.28025n 0
+ 53000.72025n 0
+ 53500.28025n 0
+ 54000.72025n 0
+ 54500.28025n 0
+ 55000.72025n 0
+ 55500.28025n 0
+ 56000.72025n 0
+ 56500.28025n 0
+ 57000.72025n 0
+ 57500.28025n 0
+ 58000.72025n 0
+ 58500.28025n 0
+ 59000.72025n 0
+ 59500.28025n 0
+ 60000.72025n 0
+ 60500.28025n 0
+ 61000.72025n 0
+ 61500.28025n 0
+ 62000.72025n 0
+ 62500.28025n 0
+ 63000.72025n 0
+ 63500.28025n 0
+ 64000.72025n 0
+ 64500.28025n 0
+ 65000.72025n 0
+ 65500.28025n 0
+ 66000.72025n 0
+ 66500.28025n 0
+ 67000.72025n 0
+ 67500.28025n 0
+ 68000.72025n 0
+ 68500.28025n 0
+ 69000.72025n 0
+ 69500.28025n 0
+ 70000.72025n 0
+ 70500.28025n 0
+ 71000.72025n 0
+ 71500.28025n 0
+ 72000.72025n 0
+ 72500.28025n 0
+ 73000.72025n 0
+ 73500.28025n 0
+ 74000.72025n 0
+ 74500.28025n 0
+ 75000.72025n 0
+ 75500.28025n 0
+ 76000.72025n 0
+ 76500.28025n 0
+ 77000.72025n 0
+ 77500.28025n 0
+ 78000.72025n 0
+ 78500.28025n 0
+ 79000.72025n 0
+ 79500.28025n 0
+ 80000.72025n 0
+ 80500.28025n 0
+ 81000.72025n 0
+ 81500.28025n 0
+ 82000.72025n 0
+ 82500.28025n 0
+ 83000.72025n 0
+ 83500.28025n 0
+ 84000.72025n 0
+ 84500.28025n 0
+ 85000.72025n 0
+ 85500.28025n 0
+ 86000.72025n 0
+ 86500.28025n 0
+ 87000.72025n 0
+ 87500.28025n 0
+ 88000.72025n 0
+ 88500.28025n 0
+ 89000.72025n 0
+ 89500.28025n 0
+ 90000.72025n 0
+ 90500.28025n 0
+ 91000.72025n 0
+ 91500.28025n 0
+ 92000.72025n 0
+ 92500.28025n 0
+ 93000.72025n 0
+ 93500.28025n 0
+ 94000.72025n 0
+ 94500.28025n 0
+ 95000.72025n 0
+ 95500.28025n 0
+ 96000.72025n 0
+ 96500.28025n 0
+ 97000.72025n 0
+ 97500.28025n 0
+ 98000.72025n 0
+ 98500.28025n 0
+ 99000.72025n 0
+ 99500.28025n 0
+ 100000.72025n 0
+ 100500.28025n 0
+ 101000.72025n 0
+ 101500.28025n 0
+ 102000.72025n 0
+ 102500.28025n 0
+ 103000.72025n 0
+ 103500.28025n 0
+ 104000.72025n 0
+ 104500.28025n 0
+ 105000.72025n 0
+ 105500.28025n 0
+ 106000.72025n 0
+ 106500.28025n 0
+ 107000.72025n 0
+ 107500.28025n 0
+ 108000.72025n 0
+ 108500.28025n 0
+ 109000.72025n 0
+ 109500.28025n 0
+ 110000.72025n 0
+ 110500.28025n 0
+ 111000.72025n 0
+ 111500.28025n 0
+ 112000.72025n 0
+ 112500.28025n 0
+ 113000.72025n 0
+ 113500.28025n 0
+ 114000.72025n 0
+ 114500.28025n 0
+ 115000.72025n 0
+ 115500.28025n 0
+ 116000.72025n 0
+ 116500.28025n 0
+ 117000.72025n 0
+ 117500.28025n 0
+ 118000.72025n 0
+ 118500.28025n 0
+ 119000.72025n 0
+ 119500.28025n 0
+ 120000.72025n 0
+ 120500.28025n 0
+ 121000.72025n 0
+ 121500.28025n 0
+ 122000.72025n 0
+ 122500.28025n 0
+ 123000.72025n 0
+ 123500.28025n 0
+ 124000.72025n 0
+ 124500.28025n 0
+ 125000.72025n 0
+ 125500.28025n 0
+ 126000.72025n 0
+ 126500.28025n 0
+ 127000.72025n 0
+ 127500.28025n 0
+ 128000.72025n 0
+ 128500.28025n 0
+ 129000.72025n 0
+ 129500.28025n 0
+ 130000.72025n 0
+ 130500.28025n 0
+ 131000.72025n 0
+ 131500.28025n 0
+ 132000.72025n 0
+ 132500.28025n 0
+ 133000.72025n 0
+ 133500.28025n 0
+ 134000.72025n 0
+ 134500.28025n 0
+ 135000.72025n 0
+ 135500.28025n 0
+ 136000.72025n 0
+ 136500.28025n 0
+ 137000.72025n 0
+ 137500.28025n 0
+ 138000.72025n 0
+ 138500.28025n 0
+ 139000.72025n 0
+ 139500.28025n 0
+ 140000.72025n 0
+ 140500.28025n 0
+ 141000.72025n 0
+ 141500.28025n 0
+ 142000.72025n 0
+ 142500.28025n 0
+ 143000.72025n 0
+ 143500.28025n 0
+ 144000.72025n 0
+ 144500.28025n 0
+ 145000.72025n 0
+ 145500.28025n 0
+ 146000.72025n 0
+ 146500.28025n 0
+ 147000.72025n 0
+ 147500.28025n 0
+ 148000.72025n 0
+ 148500.28025n 0
+ 149000.72025n 0
+ 149500.28025n 0
+ 150000.72025n 0
+ 150500.28025n 0
+ 151000.72025n 0
+ 151500.28025n 0
+ 152000.72025n 0
+ 152500.28025n 0
+ 153000.72025n 0
+ 153500.28025n 0
+ 154000.72025n 0
+ 154500.28025n 0
+ 155000.72025n 0
+ 155500.28025n 0
+ 156000.72025n 0
+ 156500.28025n 0
+ 157000.72025n 0
+ 157500.28025n 0
+ 158000.72025n 0
+ 158500.28025n 0
+ 159000.72025n 0
+ 159500.28025n 0
+ 160000.72025n 0
+ 160500.28025n 0
+ 161000.72025n 0
+ 161500.28025n 0
+ 162000.72025n 0
+ 162500.28025n 0
+ 163000.72025n 0
+ 163500.28025n 0
+ 164000.72025n 0
+ 164500.28025n 0
+ 165000.72025n 0
+ 165500.28025n 0
+ 166000.72025n 0
+ 166500.28025n 0
+ 167000.72025n 0
+ 167500.28025n 0
+ 168000.72025n 0
+ 168500.28025n 0
+ 169000.72025n 0
+ 169500.28025n 0
+ 170000.72025n 0
+ 170500.28025n 0
+ 171000.72025n 0
+ 171500.28025n 0
+ 172000.72025n 0
+ 172500.28025n 0
+ 173000.72025n 0
+ 173500.28025n 0
+ 174000.72025n 0
+ 174500.28025n 0
+ 175000.72025n 0
+ 175500.28025n 0
+ 176000.72025n 0
+ 176500.28025n 0
+ 177000.72025n 0
+ 177500.28025n 0
+ 178000.72025n 0
+ 178500.28025n 0
+ 179000.72025n 0
+ 179500.28025n 0
+ 180000.72025n 0
+ 180500.28025n 0
+ 181000.72025n 0
+ 181500.28025n 0
+ 182000.72025n 0
+ 182500.28025n 0
+ 183000.72025n 0
+ 183500.28025n 0
+ 184000.72025n 0
+ 184500.28025n 0
+ 185000.72025n 0
+ 185500.28025n 0
+ 186000.72025n 0
+ 186500.28025n 0
+ 187000.72025n 0
+ 187500.28025n 0
+ 188000.72025n 0
+ 188500.28025n 0
+ 189000.72025n 0
+ 189500.28025n 0
+ 190000.72025n 0
+ 190500.28025n 0
+ 191000.72025n 0
+ 191500.28025n 0
+ 192000.72025n 0
+ 192500.28025n 0
+ 193000.72025n 0
+ 193500.28025n 0
+ 194000.72025n 0
+ 194500.28025n 0
+ 195000.72025n 0
+ 195500.28025n 0
+ 196000.72025n 0
+ 196500.28025n 0
+ 197000.72025n 0
+ 197500.28025n 0
+ 198000.72025n 0
+ 198500.28025n 0
+ 199000.72025n 0
+ 199500.28025n 0
+ 200000.72025n 0
+ 200500.28025n 0
+ 201000.72025n 0
+ 201500.28025n 0
+ 202000.72025n 0
+ 202500.28025n 0
+ 203000.72025n 0
+ 203500.28025n 0
+ 204000.72025n 0
+ 204500.28025n 0
+ 205000.72025n 0
+ 205500.28025n 0
+ 206000.72025n 0
+ 206500.28025n 0
+ 207000.72025n 0
+ 207500.28025n 0
+ 208000.72025n 0
+ 208500.28025n 0
+ 209000.72025n 0
+ 209500.28025n 0
+ 210000.72025n 0
+ 210500.28025n 0
+ 211000.72025n 0
+ 211500.28025n 0
+ 212000.72025n 0
+ 212500.28025n 0
+ 213000.72025n 0
+ 213500.28025n 0
+ 214000.72025n 0
+ 214500.28025n 0
+ 215000.72025n 0
+ 215500.28025n 0
+ 216000.72025n 0
+ 216500.28025n 0
+ 217000.72025n 0
+ 217500.28025n 0
+ 218000.72025n 0
+ 218500.28025n 0
+ 219000.72025n 0
+ 219500.28025n 0
+ 220000.72025n 0
+ 220500.28025n 0
+ 221000.72025n 0
+ 221500.28025n 0
+ 222000.72025n 0
+ 222500.28025n 0
+ 223000.72025n 0
+ 223500.28025n 0
+ 224000.72025n 0
+ 224500.28025n 0
+ 225000.72025n 0
+ 225500.28025n 0
+ 226000.72025n 0
+ 226500.28025n 0
+ 227000.72025n 0
+ 227500.28025n 0
+ 228000.72025n 0
+ 228500.28025n 0
+ 229000.72025n 0
+ 229500.28025n 0
+ 230000.72025n 0
+ 230500.28025n 0
+ 231000.72025n 0
+ 231500.28025n 0
+ 232000.72025n 0
+ 232500.28025n 0
+ 233000.72025n 0
+ 233500.28025n 0
+ 234000.72025n 0
+ 234500.28025n 0
+ 235000.72025n 0
+ 235500.28025n 0
+ 236000.72025n 0
+ 236500.28025n 0
+ 237000.72025n 0
+ 237500.28025n 0
+ 238000.72025n 0
+ 238500.28025n 0
+ 239000.72025n 0
+ 239500.28025n 0
+ 240000.72025n 0
+ 240500.28025n 0
+ 241000.72025n 0
+ 241500.28025n 0
+ 242000.72025n 0
+ 242500.28025n 0
+ 243000.72025n 0
+ 243500.28025n 0
+ 244000.72025n 0
+ 244500.28025n 0
+ 245000.72025n 0
+ 245500.28025n 0
+ 246000.72025n 0
+ 246500.28025n 0
+ 247000.72025n 0
+ 247500.28025n 0
+ 248000.72025n 0
+ 248500.28025n 0
+ 249000.72025n 0
+ 249500.28025n 0
+ 250000.72025n 0
+ 250500.28025n 0
+ 251000.72025n 0
+ 251500.28025n 0
+ 252000.72025n 0
+ 252500.28025n 0
+ 253000.72025n 0
+ 253500.28025n 0
+ 254000.72025n 0
+ 254500.28025n 0
+ 255000.72025n 0
+ 255500.28025n 0
+ 256000.72025n 0
+ 256500.28025n 0
+ 257000.72025n 0
+ 257500.28025n 0
+ 258000.72025n 0
+ 258500.28025n 0
+ 259000.72025n 0
+ 259500.28025n 0
+ 260000.72025n 0
+ 260500.28025n 0
+ 261000.72025n 0
+ 261500.28025n 0
+ 262000.72025n 0
+ 262500.28025n 0
+ 263000.72025n 0
+ 263500.28025n 0
+ 264000.72025n 0
+ 264500.28025n 0
+ 265000.72025n 0
+ 265500.28025n 0
+ 266000.72025n 0
+ 266500.28025n 0
+ 267000.72025n 0
+ 267500.28025n 0
+ 268000.72025n 0
+ 268500.28025n 0
+ 269000.72025n 0
+ 269500.28025n 0
+ 270000.72025n 0
+ 270500.28025n 0
+ 271000.72025n 0
+ 271500.28025n 0
+ 272000.72025n 0
+ 272500.28025n 0
+ 273000.72025n 0
+ 273500.28025n 0
+ 274000.72025n 0
+ 274500.28025n 0
+ 275000.72025n 0
+ 275500.28025n 0
+ 276000.72025n 0
+ 276500.28025n 0
+ 277000.72025n 0
+ 277500.28025n 0
+ 278000.72025n 0
+ 278500.28025n 0
+ 279000.72025n 0
+ 279500.28025n 0
+ 280000.72025n 0
+ 280500.28025n 0
+ 281000.72025n 0
+ 281500.28025n 0
+ 282000.72025n 0
+ 282500.28025n 0
+ 283000.72025n 0
+ 283500.28025n 0
+ 284000.72025n 0
+ 284500.28025n 0
+ 285000.72025n 0
+ 285500.28025n 0
+ 286000.72025n 0
+ 286500.28025n 0
+ 287000.72025n 0
+ 287500.28025n 0
+ 288000.72025n 0
+ 288500.28025n 0
+ 289000.72025n 0
+ 289500.28025n 0
+ 290000.72025n 0
+ 290500.28025n 0
+ 291000.72025n 0
+ 291500.28025n 0
+ 292000.72025n 0
+ 292500.28025n 0
+ 293000.72025n 0
+ 293500.28025n 0
+ 294000.72025n 0
+ 294500.28025n 0
+ 295000.72025n 0
+ 295500.28025n 0
+ 296000.72025n 0
+ 296500.28025n 0
+ 297000.72025n 0
+ 297500.28025n 0
+ 298000.72025n 0
+ 298500.28025n 0
+ 299000.72025n 0
+ 299500.28025n 0
+ 300000.72025n 0
+ 300500.28025n 0
+ 301000.72025n 0
+ 301500.28025n 0
+ 302000.72025n 0
+ 302500.28025n 0
+ 303000.72025n 0
+ 303500.28025n 0
+ 304000.72025n 0
+ 304500.28025n 0
+ 305000.72025n 0
+ 305500.28025n 0
+ 306000.72025n 0
+ 306500.28025n 0
+ 307000.72025n 0
+ 307500.28025n 0
+ 308000.72025n 0
+ 308500.28025n 0
+ 309000.72025n 0
+ 309500.28025n 0
+ 310000.72025n 0
+ 310500.28025n 0
+ 311000.72025n 0
+ 311500.28025n 0
+ 312000.72025n 0
+ 312500.28025n 0
+ 313000.72025n 0
+ 313500.28025n 0
+ 314000.72025n 0
+ 314500.28025n 0
+ 315000.72025n 0
+ 315500.28025n 0
+ 316000.72025n 0
+ 316500.28025n 0
+ 317000.72025n 0
+ 317500.28025n 0
+ 318000.72025n 0
+ 318500.28025n 0
+ 319000.72025n 0
+ 319500.28025n 0
+ 320000.72025n 0
+ 320500.28025n 0
+ 321000.72025n 0
+ 321500.28025n 0
+ 322000.72025n 0
+ 322500.28025n 0
+ 323000.72025n 0
+ 323500.28025n 0
+ 324000.72025n 0
+ 324500.28025n 0
+ 325000.72025n 0
+ 325500.28025n 0
+ 326000.72025n 0
+ 326500.28025n 0
+ 327000.72025n 0
+ 327500.28025n 0
+ 328000.72025n 0
+ 328500.28025n 0
+ 329000.72025n 0
+ 329500.28025n 0
+ 330000.72025n 0
+ 330500.28025n 0
+ 331000.72025n 0
+ 331500.28025n 0
+ 332000.72025n 0
+ 332500.28025n 0
+ 333000.72025n 0
+ 333500.28025n 0
+ 334000.72025n 0
+ 334500.28025n 0
+ 335000.72025n 0
+ 335500.28025n 0
+ 336000.72025n 0
+ 336500.28025n 0
+ 337000.72025n 0
+ 337500.28025n 0
+ 338000.72025n 0
+ 338500.28025n 0
+ 339000.72025n 0
+ 339500.28025n 0
+ 340000.72025n 0
+ 340500.28025n 0
+ 341000.72025n 0
+ 341500.28025n 0
+ 342000.72025n 0
+ 342500.28025n 0
+ 343000.72025n 0
+ 343500.28025n 0
+ 344000.72025n 0
+ 344500.28025n 0
+ 345000.72025n 0
+ 345500.28025n 0
+ 346000.72025n 0
+ 346500.28025n 0
+ 347000.72025n 0
+ 347500.28025n 0
+ 348000.72025n 0
+ 348500.28025n 0
+ 349000.72025n 0
+ 349500.28025n 0
+ 350000.72025n 0
+ 350500.28025n 0
+ 351000.72025n 0
+ 351500.28025n 0
+ 352000.72025n 0
+ 352500.28025n 0
+ 353000.72025n 0
+ 353500.28025n 0
+ 354000.72025n 0
+ 354500.28025n 0
+ 355000.72025n 0
+ 355500.28025n 0
+ 356000.72025n 0
+ 356500.28025n 0
+ 357000.72025n 0
+ 357500.28025n 0
+ 358000.72025n 0
+ 358500.28025n 0
+ 359000.72025n 0
+ 359500.28025n 0
+ 360000.72025n 0
+ 360500.28025n 0
+ 361000.72025n 0
+ 361500.28025n 0
+ 362000.72025n 0
+ 362500.28025n 0
+ 363000.72025n 0
+ 363500.28025n 0
+ 364000.72025n 0
+ 364500.28025n 0
+ 365000.72025n 0
+ 365500.28025n 0
+ 366000.72025n 0
+ 366500.28025n 0
+ 367000.72025n 0
+ 367500.28025n 0
+ 368000.72025n 0
+ 368500.28025n 0
+ 369000.72025n 0
+ 369500.28025n 0
+ 370000.72025n 0
+ 370500.28025n 0
+ 371000.72025n 0
+ 371500.28025n 0
+ 372000.72025n 0
+ 372500.28025n 0
+ 373000.72025n 0
+ 373500.28025n 0
+ 374000.72025n 0
+ 374500.28025n 0
+ 375000.72025n 0
+ 375500.28025n 0
+ 376000.72025n 0
+ 376500.28025n 0
+ 377000.72025n 0
+ 377500.28025n 0
+ 378000.72025n 0
+ 378500.28025n 0
+ 379000.72025n 0
+ 379500.28025n 0
+ 380000.72025n 0
+ 380500.28025n 0
+ 381000.72025n 0
+ 381500.28025n 0
+ 382000.72025n 0
+ 382500.28025n 0
+ 383000.72025n 0
+ 383500.28025n 0
+ 384000.72025n 0
+ 384500.28025n 0
+ 385000.72025n 0
+ 385500.28025n 0
+ 386000.72025n 0
+ 386500.28025n 0
+ 387000.72025n 0
+ 387500.28025n 0
+ 388000.72025n 0
+ 388500.28025n 0
+ 389000.72025n 0
+ 389500.28025n 0
+ 390000.72025n 0
+ 390500.28025n 0
+ 391000.72025n 0
+ 391500.28025n 0
+ 392000.72025n 0
+ 392500.28025n 0
+ 393000.72025n 0
+ 393500.28025n 0
+ 394000.72025n 0
+ 394500.28025n 0
+ 395000.72025n 0
+ 395500.28025n 0
+ 396000.72025n 0
+ 396500.28025n 0
+ 397000.72025n 0
+ 397500.28025n 0
+ 398000.72025n 0
+ 398500.28025n 0
+ 399000.72025n 0
+ 399500.28025n 0
+ 400000.72025n 0
+ 400500.28025n 0
+ 401000.72025n 0
+ 401500.28025n 0
+ 402000.72025n 0
+ 402500.28025n 0
+ 403000.72025n 0
+ 403500.28025n 0
+ 404000.72025n 0
+ 404500.28025n 0
+ 405000.72025n 0
+ 405500.28025n 0
+ 406000.72025n 0
+ 406500.28025n 0
+ 407000.72025n 0
+ 407500.28025n 0
+ 408000.72025n 0
+ 408500.28025n 0
+ 409000.72025n 0
+ 409500.28025n 0
+ 410000.72025n 0
+ 410500.28025n 0
+ 411000.72025n 0
+ 411500.28025n 0
+ 412000.72025n 0
+ 412500.28025n 0
+ 413000.72025n 0
+ 413500.28025n 0
+ 414000.72025n 0
+ 414500.28025n 0
+ 415000.72025n 0
+ 415500.28025n 0
+ 416000.72025n 0
+ 416500.28025n 0
+ 417000.72025n 0
+ 417500.28025n 0
+ 418000.72025n 0
+ 418500.28025n 0
+ 419000.72025n 0
+ 419500.28025n 0
+ 420000.72025n 0
+ 420500.28025n 0
+ 421000.72025n 0
+ 421500.28025n 0
+ 422000.72025n 0
+ 422500.28025n 0
+ 423000.72025n 0
+ 423500.28025n 0
+ 424000.72025n 0
+ 424500.28025n 0
+ 425000.72025n 0
+ 425500.28025n 0
+ 426000.72025n 0
+ 426500.28025n 0
+ 427000.72025n 0
+ 427500.28025n 0
+ 428000.72025n 0
+ 428500.28025n 0
+ 429000.72025n 0
+ 429500.28025n 0
+ 430000.72025n 0
+ 430500.28025n 0
+ 431000.72025n 0
+ 431500.28025n 0
+ 432000.72025n 0
+ 432500.28025n 0
+ 433000.72025n 0
+ 433500.28025n 0
+ 434000.72025n 0
+ 434500.28025n 0
+ 435000.72025n 0
+ 435500.28025n 0
+ 436000.72025n 0
+ 436500.28025n 0
+ 437000.72025n 0
+ 437500.28025n 0
+ 438000.72025n 0
+ 438500.28025n 0
+ 439000.72025n 0
+ 439500.28025n 0
+ 440000.72025n 0
+ 440500.28025n 0
+ 441000.72025n 0
+ 441500.28025n 0
+ 442000.72025n 0
+ 442500.28025n 0
+ 443000.72025n 0
+ 443500.28025n 0
+ 444000.72025n 0
+ 444500.28025n 0
+ 445000.72025n 0
+ 445500.28025n 0
+ 446000.72025n 0
+ 446500.28025n 0
+ 447000.72025n 0
+ 447500.28025n 0
+ 448000.72025n 0
+ 448500.28025n 0
+ 449000.72025n 0
+ 449500.28025n 0
+ 450000.72025n 0
+ 450500.28025n 0
+ 451000.72025n 0
+ 451500.28025n 0
+ 452000.72025n 0
+ 452500.28025n 0
+ 453000.72025n 0
+ 453500.28025n 0
+ 454000.72025n 0
+ 454500.28025n 0
+ 455000.72025n 0
+ 455500.28025n 0
+ 456000.72025n 0
+ 456500.28025n 0
+ 457000.72025n 0
+ 457500.28025n 0
+ 458000.72025n 0
+ 458500.28025n 0
+ 459000.72025n 0
+ 459500.28025n 0
+ 460000.72025n 0
+ 460500.28025n 0
+ 461000.72025n 0
+ 461500.28025n 0
+ 462000.72025n 0
+ 462500.28025n 0
+ 463000.72025n 0
+ 463500.28025n 0
+ 464000.72025n 0
+ 464500.28025n 0
+ 465000.72025n 0
+ 465500.28025n 0
+ 466000.72025n 0
+ 466500.28025n 0
+ 467000.72025n 0
+ 467500.28025n 0
+ 468000.72025n 0
+ 468500.28025n 0
+ 469000.72025n 0
+ 469500.28025n 0
+ 470000.72025n 0
+ 470500.28025n 0
+ 471000.72025n 0
+ 471500.28025n 0
+ 472000.72025n 0
+ 472500.28025n 0
+ 473000.72025n 0
+ 473500.28025n 0
+ 474000.72025n 0
+ 474500.28025n 0
+ 475000.72025n 0
+ 475500.28025n 0
+ 476000.72025n 0
+ 476500.28025n 0
+ 477000.72025n 0
+ 477500.28025n 0
+ 478000.72025n 0
+ 478500.28025n 0
+ 479000.72025n 0
+ 479500.28025n 0
+ 480000.72025n 0
+ 480500.28025n 0
+ 481000.72025n 0
+ 481500.28025n 0
+ 482000.72025n 0
+ 482500.28025n 0
+ 483000.72025n 0
+ 483500.28025n 0
+ 484000.72025n 0
+ 484500.28025n 0
+ 485000.72025n 0
+ 485500.28025n 0
+ 486000.72025n 0
+ 486500.28025n 0
+ 487000.72025n 0
+ 487500.28025n 0
+ 488000.72025n 0
+ 488500.28025n 0
+ 489000.72025n 0
+ 489500.28025n 0
+ 490000.72025n 0
+ 490500.28025n 0
+ 491000.72025n 0
+ 491500.28025n 0
+ 492000.72025n 0
+ 492500.28025n 0
+ 493000.72025n 0
+ 493500.28025n 0
+ 494000.72025n 0
+ 494500.28025n 0
+ 495000.72025n 0
+ 495500.28025n 0
+ 496000.72025n 0
+ 496500.28025n 0
+ 497000.72025n 0
+ 497500.28025n 0
+ 498000.72025n 0
+ 498500.28025n 0
+ 499000.72025n 0
+ 499500.28025n 0
+ 500000.72025n 0
+ 500500.28025n 0
+ 501000.72025n 0
+ 501500.28025n 0
+ 502000.72025n 0
+ 502500.28025n 0
+ 503000.72025n 0
+ 503500.28025n 0
+ 504000.72025n 0
+ 504500.28025n 0
+ 505000.72025n 0
+ 505500.28025n 0
+ 506000.72025n 0
+ 506500.28025n 0
+ 507000.72025n 0
+ 507500.28025n 0
+ 508000.72025n 0
+ 508500.28025n 0
+ 509000.72025n 0
+ 509500.28025n 0
+ 510000.72025n 0
+ 510500.28025n 0
+ 511000.72025n 0
+ 511500.28025n 0
+ 512000.72025n 0
+ 512500.28025n 0
+ 513000.72025n 0
+ 513500.28025n 0
+ 514000.72025n 0
+ 514500.28025n 0
+ 515000.72025n 0
+ 515500.28025n 0
+ 516000.72025n 0
+ 516500.28025n 0
+ 517000.72025n 0
+ 517500.28025n 0
+ 518000.72025n 0
+ 518500.28025n 0
+ 519000.72025n 0
+ 519500.28025n 0
+ 520000.72025n 0
+ 520500.28025n 0
+ 521000.72025n 0
+ 521500.28025n 0
+ 522000.72025n 0
+ 522500.28025n 0
+ 523000.72025n 0
+ 523500.28025n 0
+ 524000.72025n 0
+ 524500.28025n 0
+ 525000.72025n 0
+ 525500.28025n 0
+ 526000.72025n 0
+ 526500.28025n 0
+ 527000.72025n 0
+ 527500.28025n 0
+ 528000.72025n 0
+ 528500.28025n 0
+ 529000.72025n 0
+ 529500.28025n 0
+ 530000.72025n 0
+ 530500.28025n 0
+ 531000.72025n 0
+ 531500.28025n 0
+ 532000.72025n 0
+ 532500.28025n 0
+ 533000.72025n 0
+ 533500.28025n 0
+ 534000.72025n 0
+ 534500.28025n 0
+ 535000.72025n 0
+ 535500.28025n 0
+ 536000.72025n 0
+ 536500.28025n 0
+ 537000.72025n 0
+ 537500.28025n 0
+ 538000.72025n 0
+ 538500.28025n 0
+ 539000.72025n 0
+ 539500.28025n 0
+ 540000.72025n 0
+ 540500.28025n 0
+ 541000.72025n 0
+ 541500.28025n 0
+ 542000.72025n 0
+ 542500.28025n 0
+ 543000.72025n 0
+ 543500.28025n 0
+ 544000.72025n 0
+ 544500.28025n 0
+ 545000.72025n 0
+ 545500.28025n 0
+ 546000.72025n 0
+ 546500.28025n 0
+ 547000.72025n 0
+ 547500.28025n 0
+ 548000.72025n 0
+ 548500.28025n 0
+ 549000.72025n 0
+ 549500.28025n 0
+ 550000.72025n 0
+ 550500.28025n 0
+ 551000.72025n 0
+ 551500.28025n 0
+ 552000.72025n 0
+ 552500.28025n 0
+ 553000.72025n 0
+ 553500.28025n 0
+ 554000.72025n 0
+ 554500.28025n 0
+ 555000.72025n 0
+ 555500.28025n 0
+ 556000.72025n 0
+ 556500.28025n 0
+ 557000.72025n 0
+ 557500.28025n 0
+ 558000.72025n 0
+ 558500.28025n 0
+ 559000.72025n 0
+ 559500.28025n 0
+ 560000.72025n 0
+ 560500.28025n 0
+ 561000.72025n 0
+ 561500.28025n 0
+ 562000.72025n 0
+ 562500.28025n 0
+ 563000.72025n 0
+ 563500.28025n 0
+ 564000.72025n 0
+ 564500.28025n 0
+ 565000.72025n 0
+ 565500.28025n 0
+ 566000.72025n 0
+ 566500.28025n 0
+ 567000.72025n 0
+ 567500.28025n 0
+ 568000.72025n 0
+ 568500.28025n 0
+ 569000.72025n 0
+ 569500.28025n 0
+ 570000.72025n 0
+ 570500.28025n 0
+ 571000.72025n 0
+ 571500.28025n 0
+ 572000.72025n 0
+ 572500.28025n 0
+ 573000.72025n 0
+ 573500.28025n 0
+ 574000.72025n 0
+ 574500.28025n 0
+ 575000.72025n 0
+ 575500.28025n 0
+ 576000.72025n 0
+ 576500.28025n 0
+ 577000.72025n 0
+ 577500.28025n 0
+ 578000.72025n 0
+ 578500.28025n 0
+ 579000.72025n 0
+ 579500.28025n 0
+ 580000.72025n 0
+ 580500.28025n 0
+ 581000.72025n 0
+ 581500.28025n 0
+ 582000.72025n 0
+ 582500.28025n 0
+ 583000.72025n 0
+ 583500.28025n 0
+ 584000.72025n 0
+ 584500.28025n 0
+ 585000.72025n 0
+ 585500.28025n 0
+ 586000.72025n 0
+ 586500.28025n 0
+ 587000.72025n 0
+ 587500.28025n 0
+ 588000.72025n 0
+ 588500.28025n 0
+ 589000.72025n 0
+ 589500.28025n 0
+ 590000.72025n 0
+ 590500.28025n 0
+ 591000.72025n 0
+ 591500.28025n 0
+ 592000.72025n 0
+ 592500.28025n 0
+ 593000.72025n 0
+ 593500.28025n 0
+ 594000.72025n 0
+ 594500.28025n 0
+ 595000.72025n 0
+ 595500.28025n 0
+ 596000.72025n 0
+ 596500.28025n 0
+ 597000.72025n 0
+ 597500.28025n 0
+ 598000.72025n 0
+ 598500.28025n 0
+ 599000.72025n 0
+ 599500.28025n 0
+ 600000.72025n 0
+ 600500.28025n 0
+ 601000.72025n 0
+ 601500.28025n 0
+ 602000.72025n 0
+ 602500.28025n 0
+ 603000.72025n 0
+ 603500.28025n 0
+ 604000.72025n 0
+ 604500.28025n 0
+ 605000.72025n 0
+ 605500.28025n 0
+ 606000.72025n 0
+ 606500.28025n 0
+ 607000.72025n 0
+ 607500.28025n 0
+ 608000.72025n 0
+ 608500.28025n 0
+ 609000.72025n 0
+ 609500.28025n 0
+ 610000.72025n 0
+ 610500.28025n 0
+ 611000.72025n 0
+ 611500.28025n 0
+ 612000.72025n 0
+ 612500.28025n 0
+ 613000.72025n 0
+ 613500.28025n 0
+ 614000.72025n 0
+ 614500.28025n 0
+ 615000.72025n 0
+ 615500.28025n 0
+ 616000.72025n 0
+ 616500.28025n 0
+ 617000.72025n 0
+ 617500.28025n 0
+ 618000.72025n 0
+ 618500.28025n 0
+ 619000.72025n 0
+ 619500.28025n 0
+ 620000.72025n 0
+ 620500.28025n 0
+ 621000.72025n 0
+ 621500.28025n 0
+ 622000.72025n 0
+ 622500.28025n 0
+ 623000.72025n 0
+ 623500.28025n 0
+ 624000.72025n 0
+ 624500.28025n 0
+ 625000.72025n 0
+ 625500.28025n 0
+ 626000.72025n 0
+ 626500.28025n 0
+ 627000.72025n 0
+ 627500.28025n 0
+ 628000.72025n 0
+ 628500.28025n 0
+ 629000.72025n 0
+ 629500.28025n 0
+ 630000.72025n 0
+ 630500.28025n 0
+ 631000.72025n 0
+ 631500.28025n 0
+ 632000.72025n 0
+ 632500.28025n 0
+ 633000.72025n 0
+ 633500.28025n 0
+ 634000.72025n 0
+ 634500.28025n 0
+ 635000.72025n 0
+ 635500.28025n 0
+ 636000.72025n 0
+ 636500.28025n 0
+ 637000.72025n 0
+ 637500.28025n 0
+ 638000.72025n 0
+ 638500.28025n 0
+ 639000.72025n 0
+ 639500.28025n 0
+ 640000.72025n 0
+ 640500.28025n 0
+ 641000.72025n 0
+ 641500.28025n 0
+ 642000.72025n 0
+ 642500.28025n 0
+ 643000.72025n 0
+ 643500.28025n 0
+ 644000.72025n 0
+ 644500.28025n 0
+ 645000.72025n 0
+ 645500.28025n 0
+ 646000.72025n 0
+ 646500.28025n 0
+ 647000.72025n 0
+ 647500.28025n 0
+ 648000.72025n 0
+ 648500.28025n 0
+ 649000.72025n 0
+ 649500.28025n 0
+ 650000.72025n 0
+ 650500.28025n 0
+ 651000.72025n 0
+ 651500.28025n 0
+ 652000.72025n 0
+ 652500.28025n 0
+ 653000.72025n 0
+ 653500.28025n 0
+ 654000.72025n 0
+ 654500.28025n 0
+ 655000.72025n 0
+ 655500.28025n 0
+ 656000.72025n 0
+ 656500.28025n 0
+ 657000.72025n 0
+ 657500.28025n 0
+ 658000.72025n 0
+ 658500.28025n 0
+ 659000.72025n 0
+ 659500.28025n 0
+ 660000.72025n 0
+ 660500.28025n 0
+ 661000.72025n 0
+ 661500.28025n 0
+ 662000.72025n 0
+ 662500.28025n 0
+ 663000.72025n 0
+ 663500.28025n 0
+ 664000.72025n 0
+ 664500.28025n 0
+ 665000.72025n 0
+ 665500.28025n 0
+ 666000.72025n 0
+ 666500.28025n 0
+ 667000.72025n 0
+ 667500.28025n 0
+ 668000.72025n 0
+ 668500.28025n 0
+ 669000.72025n 0
+ 669500.28025n 0
+ 670000.72025n 0
+ 670500.28025n 0
+ 671000.72025n 0
+ 671500.28025n 0
+ 672000.72025n 0
+ 672500.28025n 0
+ 673000.72025n 0
+ 673500.28025n 0
+ 674000.72025n 0
+ 674500.28025n 0
+ 675000.72025n 0
+ 675500.28025n 0
+ 676000.72025n 0
+ 676500.28025n 0
+ 677000.72025n 0
+ 677500.28025n 0
+ 678000.72025n 0
+ 678500.28025n 0
+ 679000.72025n 0
+ 679500.28025n 0
+ 680000.72025n 0
+ 680500.28025n 0
+ 681000.72025n 0
+ 681500.28025n 0
+ 682000.72025n 0
+ 682500.28025n 0
+ 683000.72025n 0
+ 683500.28025n 0
+ 684000.72025n 0
+ 684500.28025n 0
+ 685000.72025n 0
+ 685500.28025n 0
+ 686000.72025n 0
+ 686500.28025n 0
+ 687000.72025n 0
+ 687500.28025n 0
+ 688000.72025n 0
+ 688500.28025n 0
+ 689000.72025n 0
+ 689500.28025n 0
+ 690000.72025n 0
+ 690500.28025n 0
+ 691000.72025n 0
+ 691500.28025n 0
+ 692000.72025n 0
+ 692500.28025n 0
+ 693000.72025n 0
+ 693500.28025n 0
+ 694000.72025n 0
+ 694500.28025n 0
+ 695000.72025n 0
+ 695500.28025n 0
+ 696000.72025n 0
+ 696500.28025n 0
+ 697000.72025n 0
+ 697500.28025n 0
+ 698000.72025n 0
+ 698500.28025n 0
+ 699000.72025n 0
+ 699500.28025n 0
+ 700000.72025n 0
+ 700500.28025n 0
+ 701000.72025n 0
+ 701500.28025n 0
+ 702000.72025n 0
+ 702500.28025n 0
+ 703000.72025n 0
+ 703500.28025n 0
+ 704000.72025n 0
+ 704500.28025n 0
+ 705000.72025n 0
+ 705500.28025n 0
+ 706000.72025n 0
+ 706500.28025n 0
+ 707000.72025n 0
+ 707500.28025n 0
+ 708000.72025n 0
+ 708500.28025n 0
+ 709000.72025n 0
+ 709500.28025n 0
+ 710000.72025n 0
+ 710500.28025n 0
+ 711000.72025n 0
+ 711500.28025n 0
+ 712000.72025n 0
+ 712500.28025n 0
+ 713000.72025n 0
+ 713500.28025n 0
+ 714000.72025n 0
+ 714500.28025n 0
+ 715000.72025n 0
+ 715500.28025n 0
+ 716000.72025n 0
+ 716500.28025n 0
+ 717000.72025n 0
+ 717500.28025n 0
+ 718000.72025n 0
+ 718500.28025n 0
+ 719000.72025n 0
+ 719500.28025n 0
+ 720000.72025n 0
+ 720500.28025n 0
+ 721000.72025n 0
+ 721500.28025n 0
+ 722000.72025n 0
+ 722500.28025n 0
+ 723000.72025n 0
+ 723500.28025n 0
+ 724000.72025n 0
+ 724500.28025n 0
+ 725000.72025n 0
+ 725500.28025n 0
+ 726000.72025n 0
+ 726500.28025n 0
+ 727000.72025n 0
+ 727500.28025n 0
+ 728000.72025n 0
+ 728500.28025n 0
+ 729000.72025n 0
+ 729500.28025n 0
+ 730000.72025n 0
+ 730500.28025n 0
+ 731000.72025n 0
+ 731500.28025n 0
+ 732000.72025n 0
+ 732500.28025n 0
+ 733000.72025n 0
+ 733500.28025n 0
+ 734000.72025n 0
+ 734500.28025n 0
+ 735000.72025n 0
+ 735500.28025n 0
+ 736000.72025n 0
+ 736500.28025n 0
+ 737000.72025n 0
+ 737500.28025n 0
+ 738000.72025n 0
+ 738500.28025n 0
+ 739000.72025n 0
+ 739500.28025n 0
+ 740000.72025n 0
+ 740500.28025n 0
+ 741000.72025n 0
+ 741500.28025n 0
+ 742000.72025n 0
+ 742500.28025n 0
+ 743000.72025n 0
+ 743500.28025n 0
+ 744000.72025n 0
+ 744500.28025n 0
+ 745000.72025n 0
+ 745500.28025n 0
+ 746000.72025n 0
+ 746500.28025n 0
+ 747000.72025n 0
+ 747500.28025n 0
+ 748000.72025n 0
+ 748500.28025n 0
+ 749000.72025n 0
+ 749500.28025n 0
+ 750000.72025n 0
+ 750500.28025n 0
+ 751000.72025n 0
+ 751500.28025n 0
+ 752000.72025n 0
+ 752500.28025n 0
+ 753000.72025n 0
+ 753500.28025n 0
+ 754000.72025n 0
+ 754500.28025n 0
+ 755000.72025n 0
+ 755500.28025n 0
+ 756000.72025n 0
+ 756500.28025n 0
+ 757000.72025n 0
+ 757500.28025n 0
+ 758000.72025n 0
+ 758500.28025n 0
+ 759000.72025n 0
+ 759500.28025n 0
+ 760000.72025n 0
+ 760500.28025n 0
+ 761000.72025n 0
+ 761500.28025n 0
+ 762000.72025n 0
+ 762500.28025n 0
+ 763000.72025n 0
+ 763500.28025n 0
+ 764000.72025n 0
+ 764500.28025n 0
+ 765000.72025n 0
+ 765500.28025n 0
+ 766000.72025n 0
+ 766500.28025n 0
+ 767000.72025n 0
+ 767500.28025n 0
+ 768000.72025n 0
+ 768500.28025n 0
+ 769000.72025n 0
+ 769500.28025n 0
+ 770000.72025n 0
+ 770500.28025n 0
+ 771000.72025n 0
+ 771500.28025n 0
+ 772000.72025n 0
+ 772500.28025n 0
+ 773000.72025n 0
+ 773500.28025n 0
+ 774000.72025n 0
+ 774500.28025n 0
+ 775000.72025n 0
+ 775500.28025n 0
+ 776000.72025n 0
+ 776500.28025n 0
+ 777000.72025n 0
+ 777500.28025n 0
+ 778000.72025n 0
+ 778500.28025n 0
+ 779000.72025n 0
+ 779500.28025n 0
+ 780000.72025n 0
+ 780500.28025n 0
+ 781000.72025n 0
+ 781500.28025n 0
+ 782000.72025n 0
+ 782500.28025n 0
+ 783000.72025n 0
+ 783500.28025n 0
+ 784000.72025n 0
+ 784500.28025n 0
+ 785000.72025n 0
+ 785500.28025n 0
+ 786000.72025n 0
+ 786500.28025n 0
+ 787000.72025n 0
+ 787500.28025n 0
+ 788000.72025n 0
+ 788500.28025n 0
+ 789000.72025n 0
+ 789500.28025n 0
+ 790000.72025n 0
+ 790500.28025n 0
+ 791000.72025n 0
+ 791500.28025n 0
+ 792000.72025n 0
+ 792500.28025n 0
+ 793000.72025n 0
+ 793500.28025n 0
+ 794000.72025n 0
+ 794500.28025n 0
+ 795000.72025n 0
+ 795500.28025n 0
+ 796000.72025n 0
+ 796500.28025n 0
+ 797000.72025n 0
+ 797500.28025n 0
+ 798000.72025n 0
+ 798500.28025n 0
+ 799000.72025n 0
+ 799500.28025n 0
+ 800000.72025n 0
+ 800500.28025n 0
+ 801000.72025n 0
+ 801500.28025n 0
+ 802000.72025n 0
+ 802500.28025n 0
+ 803000.72025n 0
+ 803500.28025n 0
+ 804000.72025n 0
+ 804500.28025n 0
+ 805000.72025n 0
+ 805500.28025n 0
+ 806000.72025n 0
+ 806500.28025n 0
+ 807000.72025n 0
+ 807500.28025n 0
+ 808000.72025n 0
+ 808500.28025n 0
+ 809000.72025n 0
+ 809500.28025n 0
+ 810000.72025n 0
+ 810500.28025n 0
+ 811000.72025n 0
+ 811500.28025n 0
+ 812000.72025n 0
+ 812500.28025n 0
+ 813000.72025n 0
+ 813500.28025n 0
+ 814000.72025n 0
+ 814500.28025n 0
+ 815000.72025n 0
+ 815500.28025n 0
+ 816000.72025n 0
+ 816500.28025n 0
+ 817000.72025n 0
+ 817500.28025n 0
+ 818000.72025n 0
+ 818500.28025n 0
+ 819000.72025n 0
+ 819500.28025n 0
+ 820000.72025n 0
+ 820500.28025n 0
+ 821000.72025n 0
+ 821500.28025n 0
+ 822000.72025n 0
+ 822500.28025n 0
+ 823000.72025n 0
+ 823500.28025n 0
+ 824000.72025n 0
+ 824500.28025n 0
+ 825000.72025n 0
+ 825500.28025n 0
+ 826000.72025n 0
+ 826500.28025n 0
+ 827000.72025n 0
+ 827500.28025n 0
+ 828000.72025n 0
+ 828500.28025n 0
+ 829000.72025n 0
+ 829500.28025n 0
+ 830000.72025n 0
+ 830500.28025n 0
+ 831000.72025n 0
+ 831500.28025n 0
+ 832000.72025n 0
+ 832500.28025n 0
+ 833000.72025n 0
+ 833500.28025n 0
+ 834000.72025n 0
+ 834500.28025n 0
+ 835000.72025n 0
+ 835500.28025n 0
+ 836000.72025n 0
+ 836500.28025n 0
+ 837000.72025n 0
+ 837500.28025n 0
+ 838000.72025n 0
+ 838500.28025n 0
+ 839000.72025n 0
+ 839500.28025n 0
+ 840000.72025n 0
+ 840500.28025n 0
+ 841000.72025n 0
+ 841500.28025n 0
+ 842000.72025n 0
+ 842500.28025n 0
+ 843000.72025n 0
+ 843500.28025n 0
+ 844000.72025n 0
+ 844500.28025n 0
+ 845000.72025n 0
+ 845500.28025n 0
+ 846000.72025n 0
+ 846500.28025n 0
+ 847000.72025n 0
+ 847500.28025n 0
+ 848000.72025n 0
+ 848500.28025n 0
+ 849000.72025n 0
+ 849500.28025n 0
+ 850000.72025n 0
+ 850500.28025n 0
+ 851000.72025n 0
+ 851500.28025n 0
+ 852000.72025n 0
+ 852500.28025n 0
+ 853000.72025n 0
+ 853500.28025n 0
+ 854000.72025n 0
+ 854500.28025n 0
+ 855000.72025n 0
+ 855500.28025n 0
+ 856000.72025n 0
+ 856500.28025n 0
+ 857000.72025n 0
+ 857500.28025n 0
+ 858000.72025n 0
+ 858500.28025n 0
+ 859000.72025n 0
+ 859500.28025n 0
+ 860000.72025n 0
+ 860500.28025n 0
+ 861000.72025n 0
+ 861500.28025n 0
+ 862000.72025n 0
+ 862500.28025n 0
+ 863000.72025n 0
+ 863500.28025n 0
+ 864000.72025n 0
+ 864500.28025n 0
+ 865000.72025n 0
+ 865500.28025n 0
+ 866000.72025n 0
+ 866500.28025n 0
+ 867000.72025n 0
+ 867500.28025n 0
+ 868000.72025n 0
+ 868500.28025n 0
+ 869000.72025n 0
+ 869500.28025n 0
+ 870000.72025n 0
+ 870500.28025n 0
+ 871000.72025n 0
+ 871500.28025n 0
+ 872000.72025n 0
+ 872500.28025n 0
+ 873000.72025n 0
+ 873500.28025n 0
+ 874000.72025n 0
+ 874500.28025n 0
+ 875000.72025n 0
+ 875500.28025n 0
+ 876000.72025n 0
+ 876500.28025n 0
+ 877000.72025n 0
+ 877500.28025n 0
+ 878000.72025n 0
+ 878500.28025n 0
+ 879000.72025n 0
+ 879500.28025n 0
+ 880000.72025n 0
+ 880500.28025n 0
+ 881000.72025n 0
+ 881500.28025n 0
+ 882000.72025n 0
+ 882500.28025n 0
+ 883000.72025n 0
+ 883500.28025n 0
+ 884000.72025n 0
+ 884500.28025n 0
+ 885000.72025n 0
+ 885500.28025n 0
+ 886000.72025n 0
+ 886500.28025n 0
+ 887000.72025n 0
+ 887500.28025n 0
+ 888000.72025n 0
+ 888500.28025n 0
+ 889000.72025n 0
+ 889500.28025n 0
+ 890000.72025n 0
+ 890500.28025n 0
+ 891000.72025n 0
+ 891500.28025n 0
+ 892000.72025n 0
+ 892500.28025n 0
+ 893000.72025n 0
+ 893500.28025n 0
+ 894000.72025n 0
+ 894500.28025n 0
+ 895000.72025n 0
+ 895500.28025n 0
+ 896000.72025n 0
+ 896500.28025n 0
+ 897000.72025n 0
+ 897500.28025n 0
+ 898000.72025n 0
+ 898500.28025n 0
+ 899000.72025n 0
+ 899500.28025n 0
+ 900000.72025n 0
+ 900500.28025n 0
+ 901000.72025n 0
+ 901500.28025n 0
+ 902000.72025n 0
+ 902500.28025n 0
+ 903000.72025n 0
+ 903500.28025n 0
+ 904000.72025n 0
+ 904500.28025n 0
+ 905000.72025n 0
+ 905500.28025n 0
+ 906000.72025n 0
+ 906500.28025n 0
+ 907000.72025n 0
+ 907500.28025n 0
+ 908000.72025n 0
+ 908500.28025n 0
+ 909000.72025n 0
+ 909500.28025n 0
+ 910000.72025n 0
+ 910500.28025n 0
+ 911000.72025n 0
+ 911500.28025n 0
+ 912000.72025n 0
+ 912500.28025n 0
+ 913000.72025n 0
+ 913500.28025n 0
+ 914000.72025n 0
+ 914500.28025n 0
+ 915000.72025n 0
+ 915500.28025n 0
+ 916000.72025n 0
+ 916500.28025n 0
+ 917000.72025n 0
+ 917500.28025n 0
+ 918000.72025n 0
+ 918500.28025n 0
+ 919000.72025n 0
+ 919500.28025n 0
+ 920000.72025n 0
+ 920500.28025n 0
+ 921000.72025n 0
+ 921500.28025n 0
+ 922000.72025n 0
+ 922500.28025n 0
+ 923000.72025n 0
+ 923500.28025n 0
+ 924000.72025n 0
+ 924500.28025n 0
+ 925000.72025n 0
+ 925500.28025n 0
+ 926000.72025n 0
+ 926500.28025n 0
+ 927000.72025n 0
+ 927500.28025n 0
+ 928000.72025n 0
+ 928500.28025n 0
+ 929000.72025n 0
+ 929500.28025n 0
+ 930000.72025n 0
+ 930500.28025n 0
+ 931000.72025n 0
+ 931500.28025n 0
+ 932000.72025n 0
+ 932500.28025n 0
+ 933000.72025n 0
+ 933500.28025n 0
+ 934000.72025n 0
+ 934500.28025n 0
+ 935000.72025n 0
+ 935500.28025n 0
+ 936000.72025n 0
+ 936500.28025n 0
+ 937000.72025n 0
+ 937500.28025n 0
+ 938000.72025n 0
+ 938500.28025n 0
+ 939000.72025n 0
+ 939500.28025n 0
+ 940000.72025n 0
+ 940500.28025n 0
+ 941000.72025n 0
+ 941500.28025n 0
+ 942000.72025n 0
+ 942500.28025n 0
+ 943000.72025n 0
+ 943500.28025n 0
+ 944000.72025n 0
+ 944500.28025n 0
+ 945000.72025n 0
+ 945500.28025n 0
+ 946000.72025n 0
+ 946500.28025n 0
+ 947000.72025n 0
+ 947500.28025n 0
+ 948000.72025n 0
+ 948500.28025n 0
+ 949000.72025n 0
+ 949500.28025n 0
+ 950000.72025n 0
+ 950500.28025n 0
+ 951000.72025n 0
+ 951500.28025n 0
+ 952000.72025n 0
+ 952500.28025n 0
+ 953000.72025n 0
+ 953500.28025n 0
+ 954000.72025n 0
+ 954500.28025n 0
+ 955000.72025n 0
+ 955500.28025n 0
+ 956000.72025n 0
+ 956500.28025n 0
+ 957000.72025n 0
+ 957500.28025n 0
+ 958000.72025n 0
+ 958500.28025n 0
+ 959000.72025n 0
+ 959500.28025n 0
+ 960000.72025n 0
+ 960500.28025n 0
+ 961000.72025n 0
+ 961500.28025n 0
+ 962000.72025n 0
+ 962500.28025n 0
+ 963000.72025n 0
+ 963500.28025n 0
+ 964000.72025n 0
+ 964500.28025n 0
+ 965000.72025n 0
+ 965500.28025n 0
+ 966000.72025n 0
+ 966500.28025n 0
+ 967000.72025n 0
+ 967500.28025n 0
+ 968000.72025n 0
+ 968500.28025n 0
+ 969000.72025n 0
+ 969500.28025n 0
+ 970000.72025n 0
+ 970500.28025n 0
+ 971000.72025n 0
+ 971500.28025n 0
+ 972000.72025n 0
+ 972500.28025n 0
+ 973000.72025n 0
+ 973500.28025n 0
+ 974000.72025n 0
+ 974500.28025n 0
+ 975000.72025n 0
+ 975500.28025n 0
+ 976000.72025n 0
+ 976500.28025n 0
+ 977000.72025n 0
+ 977500.28025n 0
+ 978000.72025n 0
+ 978500.28025n 0
+ 979000.72025n 0
+ 979500.28025n 0
+ 980000.72025n 0
+ 980500.28025n 0
+ 981000.72025n 0
+ 981500.28025n 0
+ 982000.72025n 0
+ 982500.28025n 0
+ 983000.72025n 0
+ 983500.28025n 0
+ 984000.72025n 0
+ 984500.28025n 0
+ 985000.72025n 0
+ 985500.28025n 0
+ 986000.72025n 0
+ 986500.28025n 0
+ 987000.72025n 0
+ 987500.28025n 0
+ 988000.72025n 0
+ 988500.28025n 0
+ 989000.72025n 0
+ 989500.28025n 0
+ 990000.72025n 0
+ 990500.28025n 0
+ 991000.72025n 0
+ 991500.28025n 0
+ 992000.72025n 0
+ 992500.28025n 0
+ 993000.72025n 0
+ 993500.28025n 0
+ 994000.72025n 0
+ 994500.28025n 0
+ 995000.72025n 0
+ 995500.28025n 0
+ 996000.72025n 0
+ 996500.28025n 0
+ 997000.72025n 0
+ 997500.28025n 0
+ 998000.72025n 0
+ 998500.28025n 0
+ 999000.72025n 0
+ 999500.28025n 0
+ 1000000.28025n 0
+ 1000000.72025n 0
+ 1000500.28025n 0
+ 1001000.72025n 0
+ 1001500.28025n 0
+ 1002000.72025n 0
+ 1002500.28025n 0
+ 1003000.72025n 0
+ 1003500.28025n 0
+ 1004000.72025n 0
+ 1004500.28025n 0
+ 1005000.72025n 0
+ 1005500.28025n 0
+ )
Vsampling_grid sampling_grid 0 PWL(0 0
+ 2.5000000000000002e-10 0
+ 5.0000000000000003e-10 0
+ 7.5e-10 0
+ 1.0000000000000001e-09 0
+ 1.25e-09 0
+ 1.5e-09 0
+ 1.5624999999999999e-09 0
+ 1.75e-09 0
+ 2.0000000000000001e-09 0
+ 2.2499999999999999e-09 0
+ 2.5000000000000001e-09 0
+ 2.7499999999999998e-09 0
+ 3e-09 0
+ 3.1249999999999999e-09 0
+ 3.2500000000000002e-09 0
+ 3.4999999999999999e-09 0
+ 3.7499999999999997e-09 0
+ 4.0000000000000002e-09 0
+ 4.25e-09 0
+ 4.4999999999999998e-09 0
+ 4.6874999999999998e-09 0
+ 4.7500000000000003e-09 0
+ 5.0000000000000001e-09 0
+ 5.2499999999999999e-09 0
+ 5.4999999999999996e-09 0
+ 5.7500000000000002e-09 0
+ 6e-09 0
+ 6.2499999999999997e-09 0
+ 6.5000000000000003e-09 0
+ 6.7500000000000001e-09 0
+ 6.9999999999999998e-09 0
+ 7.2500000000000004e-09 0
+ 7.4999999999999993e-09 0
+ 7.7499999999999999e-09 0
+ 7.8124999999999996e-09 0
+ 8.0000000000000005e-09 0
+ 8.2499999999999994e-09 0
+ 8.5e-09 0
+ 8.7500000000000006e-09 0
+ 8.9999999999999995e-09 0
+ 9.2500000000000001e-09 0
+ 9.3749999999999996e-09 0
+ 9.5000000000000007e-09 0
+ 9.7499999999999996e-09 0
+ 1e-08 0
+ 1.0250000000000001e-08 0
+ 1.05e-08 0
+ 1.075e-08 0
+ 1.0864000000000001e-08 0
+ 1.09375e-08 0
+ 1.0999999999999999e-08 0
+ 1.1002999999999999e-08 0
+ 1.125e-08 0
+ 1.15e-08 0
+ 1.1749999999999999e-08 0
+ 1.2e-08 0
+ 1.2250000000000001e-08 0
+ 1.2499999999999999e-08 0
+ 1.275e-08 0
+ 1.3000000000000001e-08 0
+ 1.325e-08 0
+ 1.35e-08 0
+ 1.3750000000000001e-08 0
+ 1.4e-08 0
+ 1.4062499999999999e-08 0
+ 1.425e-08 0
+ 1.4500000000000001e-08 0
+ 1.475e-08 0
+ 1.4999999999999999e-08 0
+ 1.5250000000000001e-08 0
+ 1.55e-08 0
+ 1.5624999999999999e-08 0
+ 1.5749999999999999e-08 0
+ 1.6000000000000001e-08 0
+ 1.625e-08 0
+ 1.6499999999999999e-08 0
+ 1.6750000000000001e-08 0
+ 1.7e-08 0
+ 1.7187500000000001e-08 0
+ 1.7249999999999999e-08 0
+ 1.7500000000000001e-08 0
+ 1.775e-08 0
+ 1.7999999999999999e-08 0
+ 1.8250000000000001e-08 0
+ 1.85e-08 0
+ 1.8749999999999999e-08 0
+ 1.9000000000000001e-08 0
+ 1.925e-08 0
+ 1.9499999999999999e-08 0
+ 1.9750000000000001e-08 0
+ 2e-08 0
+ 2.0249999999999999e-08 0
+ 2.0312500000000001e-08 0
+ 2.0500000000000002e-08 0
+ 2.0750000000000001e-08 0
+ 2.0999999999999999e-08 0
+ 2.1249999999999998e-08 0
+ 2.1500000000000001e-08 0
+ 2.175e-08 0
+ 2.1874999999999999e-08 0
+ 2.1999999999999998e-08 0
+ 2.2250000000000001e-08 0
+ 2.25e-08 0
+ 2.2749999999999999e-08 0
+ 2.3000000000000001e-08 0
+ 2.325e-08 0
+ 2.3437500000000001e-08 0
+ 2.3499999999999999e-08 0
+ 2.3750000000000001e-08 0
+ 2.4e-08 0
+ 2.4249999999999999e-08 0
+ 2.4500000000000001e-08 0
+ 2.475e-08 0
+ 2.4999999999999999e-08 0
+ 2.5250000000000001e-08 0
+ 2.55e-08 0
+ 2.5749999999999999e-08 0
+ 2.6000000000000001e-08 0
+ 2.625e-08 0
+ 2.6499999999999999e-08 0
+ 2.65625e-08 0
+ 2.6750000000000001e-08 0
+ 2.7e-08 0
+ 2.7249999999999999e-08 0
+ 2.7500000000000001e-08 0
+ 2.775e-08 0
+ 2.7999999999999999e-08 0
+ 2.8124999999999999e-08 0
+ 2.8250000000000002e-08 0
+ 2.85e-08 0
+ 2.8749999999999999e-08 0
+ 2.9000000000000002e-08 0
+ 2.9250000000000001e-08 0
+ 2.9499999999999999e-08 0
+ 2.96875e-08 0
+ 2.9749999999999998e-08 0
+ 2.9999999999999997e-08 0
+ 3.0250000000000003e-08 0
+ 3.0500000000000002e-08 0
+ 3.0750000000000001e-08 0
+ 3.1e-08 0
+ 3.1249999999999999e-08 0
+ 3.1499999999999998e-08 0
+ 3.1750000000000003e-08 0
+ 3.2000000000000002e-08 0
+ 3.2250000000000001e-08 0
+ 3.25e-08 0
+ 3.2749999999999999e-08 0
+ 3.2812499999999997e-08 0
+ 3.2999999999999998e-08 0
+ 3.3250000000000003e-08 0
+ 3.3500000000000002e-08 0
+ 3.3750000000000001e-08 0
+ 3.4e-08 0
+ 3.4249999999999999e-08 0
+ 3.4375000000000002e-08 0
+ 3.4499999999999998e-08 0
+ 3.4749999999999997e-08 0
+ 3.5000000000000002e-08 0
+ 3.5250000000000001e-08 0
+ 3.55e-08 0
+ 3.5749999999999999e-08 0
+ 3.59375e-08 0
+ 3.5999999999999998e-08 0
+ 3.6249999999999997e-08 0
+ 3.6500000000000003e-08 0
+ 3.6750000000000002e-08 0
+ 3.7e-08 0
+ 3.7249999999999999e-08 0
+ 3.7499999999999998e-08 0
+ 3.7749999999999997e-08 0
+ 3.8000000000000003e-08 0
+ 3.8250000000000002e-08 0
+ 3.8500000000000001e-08 0
+ 3.875e-08 0
+ 3.8999999999999998e-08 0
+ 3.9062500000000003e-08 0
+ 3.9249999999999997e-08 0
+ 3.9500000000000003e-08 0
+ 3.9750000000000002e-08 0
+ 4.0000000000000001e-08 0
+ 4.025e-08 0
+ 4.0499999999999999e-08 0
+ 4.0625000000000001e-08 0
+ 4.0749999999999998e-08 0
+ 4.1000000000000003e-08 0
+ 4.1250000000000002e-08 0
+ 4.1500000000000001e-08 0
+ 4.175e-08 0
+ 4.1999999999999999e-08 0
+ 4.21875e-08 0
+ 4.2249999999999998e-08 0
+ 4.2499999999999997e-08 0
+ 4.2750000000000002e-08 0
+ 4.3000000000000001e-08 0
+ 4.325e-08 0
+ 4.3499999999999999e-08 0
+ 4.3749999999999998e-08 0
+ 4.3999999999999997e-08 0
+ 4.4250000000000002e-08 0
+ 4.4500000000000001e-08 0
+ 4.475e-08 0
+ 4.4999999999999999e-08 0
+ 4.5249999999999998e-08 0
+ 4.5312500000000003e-08 0
+ 4.5499999999999997e-08 0
+ 4.5750000000000003e-08 0
+ 4.6000000000000002e-08 0
+ 4.6250000000000001e-08 0
+ 4.6499999999999999e-08 0
+ 4.6749999999999998e-08 0
+ 4.6875000000000001e-08 0
+ 4.6999999999999997e-08 0
+ 4.7250000000000003e-08 0
+ 4.7500000000000002e-08 0
+ 4.7750000000000001e-08 0
+ 4.8e-08 0
+ 4.8249999999999999e-08 0
+ 4.8437499999999999e-08 0
+ 4.8499999999999998e-08 0
+ 4.8750000000000003e-08 0
+ 4.9000000000000002e-08 0
+ 4.9250000000000001e-08 0
+ 4.95e-08 0
+ 4.9749999999999999e-08 0
+ 4.9999999999999998e-08 0
+ 5.0250000000000003e-08 0
+ 5.0500000000000002e-08 0
+ 5.0750000000000001e-08 0
+ 5.1e-08 0
+ 5.1249999999999999e-08 0
+ 5.1499999999999998e-08 0
+ 5.1562500000000003e-08 0
+ 5.1749999999999997e-08 0
+ 5.2000000000000002e-08 0
+ 5.2250000000000001e-08 0
+ 5.25e-08 0
+ 5.2749999999999999e-08 0
+ 5.2999999999999998e-08 0
+ 5.3125000000000001e-08 0
+ 5.3249999999999997e-08 0
+ 5.3500000000000003e-08 0
+ 5.3750000000000002e-08 0
+ 5.4e-08 0
+ 5.4249999999999999e-08 0
+ 5.4499999999999998e-08 0
+ 5.4687499999999999e-08 0
+ 5.4749999999999997e-08 0
+ 5.5000000000000003e-08 0
+ 5.5250000000000002e-08 0
+ 5.5500000000000001e-08 0
+ 5.575e-08 0
+ 5.5999999999999999e-08 0
+ 5.6249999999999997e-08 0
+ 5.6500000000000003e-08 0
+ 5.6750000000000002e-08 0
+ 5.7000000000000001e-08 0
+ 5.725e-08 0
+ 5.7499999999999999e-08 0
+ 5.7749999999999998e-08 0
+ 5.7812500000000002e-08 0
+ 5.8000000000000003e-08 0
+ 5.8250000000000002e-08 0
+ 5.8500000000000001e-08 0
+ 5.875e-08 0
+ 5.8999999999999999e-08 0
+ 5.9249999999999998e-08 0
+ 5.9375000000000001e-08 0
+ 5.9499999999999997e-08 0
+ 5.9750000000000002e-08 0
+ 5.9999999999999995e-08 0
+ 6.025e-08 0
+ 6.0500000000000006e-08 0
+ 6.0749999999999998e-08 0
+ 6.0937499999999999e-08 0
+ 6.1000000000000004e-08 0
+ 6.1249999999999996e-08 0
+ 6.1500000000000001e-08 0
+ 6.1749999999999994e-08 0
+ 6.1999999999999999e-08 0
+ 6.2250000000000005e-08 0
+ 6.2499999999999997e-08 0
+ 6.2750000000000003e-08 0
+ 6.2999999999999995e-08 0
+ 6.3250000000000001e-08 0
+ 6.3500000000000006e-08 0
+ 6.3749999999999998e-08 0
+ 6.4000000000000004e-08 0
+ 6.4062499999999995e-08 0
+ 6.4249999999999996e-08 0
+ 6.4500000000000002e-08 0
+ 6.4749999999999994e-08 0
+ 6.5e-08 0
+ 6.5250000000000005e-08 0
+ 6.5499999999999998e-08 0
+ 6.5624999999999994e-08 0
+ 6.5750000000000003e-08 0
+ 6.5999999999999995e-08 0
+ 6.6250000000000001e-08 0
+ 6.6500000000000007e-08 0
+ 6.6749999999999999e-08 0
+ 6.7000000000000004e-08 0
+ 6.7187500000000005e-08 0
+ 6.7249999999999997e-08 0
+ 6.7500000000000002e-08 0
+ 6.7749999999999995e-08 0
+ 6.8e-08 0
+ 6.8250000000000006e-08 0
+ 6.8499999999999998e-08 0
+ 6.8750000000000004e-08 0
+ 6.8999999999999996e-08 0
+ 6.9250000000000001e-08 0
+ 6.9499999999999994e-08 0
+ 6.9749999999999999e-08 0
+ 7.0000000000000005e-08 0
+ 7.0249999999999997e-08 0
+ 7.0312500000000002e-08 0
+ 7.0500000000000003e-08 0
+ 7.0749999999999995e-08 0
+ 7.1e-08 0
+ 7.1250000000000006e-08 0
+ 7.1499999999999998e-08 0
+ 7.1750000000000004e-08 0
+ 7.1875e-08 0
+ 7.1999999999999996e-08 0
+ 7.2250000000000002e-08 0
+ 7.2499999999999994e-08 0
+ 7.275e-08 0
+ 7.3000000000000005e-08 0
+ 7.3249999999999997e-08 0
+ 7.3437499999999998e-08 0
+ 7.3500000000000003e-08 0
+ 7.3749999999999995e-08 0
+ 7.4000000000000001e-08 0
+ 7.4250000000000006e-08 0
+ 7.4499999999999999e-08 0
+ 7.4750000000000004e-08 0
+ 7.4999999999999997e-08 0
+ 7.5250000000000002e-08 0
+ 7.5499999999999994e-08 0
+ 7.575e-08 0
+ 7.6000000000000006e-08 0
+ 7.6249999999999998e-08 0
+ 7.6500000000000003e-08 0
+ 7.6562499999999995e-08 0
+ 7.6749999999999996e-08 0
+ 7.7000000000000001e-08 0
+ 7.7249999999999994e-08 0
+ 7.7499999999999999e-08 0
+ 7.7750000000000005e-08 0
+ 7.7999999999999997e-08 0
+ 7.8125000000000006e-08 0
+ 7.8250000000000003e-08 0
+ 7.8499999999999995e-08 0
+ 7.875e-08 0
+ 7.9000000000000006e-08 0
+ 7.9249999999999998e-08 0
+ 7.9500000000000004e-08 0
+ 7.9687500000000005e-08 0
+ 7.9749999999999996e-08 0
+ 8.0000000000000002e-08 0
+ 8.0249999999999994e-08 0
+ 8.05e-08 0
+ 8.0750000000000005e-08 0
+ 8.0999999999999997e-08 0
+ 8.1250000000000003e-08 0
+ 8.1499999999999995e-08 0
+ 8.1750000000000001e-08 0
+ 8.2000000000000006e-08 0
+ 8.2249999999999999e-08 0
+ 8.2500000000000004e-08 0
+ 8.2749999999999997e-08 0
+ 8.2812500000000001e-08 0
+ 8.3000000000000002e-08 0
+ 8.3249999999999994e-08 0
+ 8.35e-08 0
+ 8.3750000000000005e-08 0
+ 8.3999999999999998e-08 0
+ 8.4250000000000003e-08 0
+ 8.4374999999999999e-08 0
+ 8.4499999999999996e-08 0
+ 8.4750000000000001e-08 0
+ 8.4999999999999994e-08 0
+ 8.5249999999999999e-08 0
+ 8.5500000000000005e-08 0
+ 8.5749999999999997e-08 0
+ 8.5937499999999998e-08 0
+ 8.6000000000000002e-08 0
+ 8.6249999999999995e-08 0
+ 8.65e-08 0
+ 8.6750000000000006e-08 0
+ 8.6999999999999998e-08 0
+ 8.7250000000000004e-08 0
+ 8.7499999999999996e-08 0
+ 8.7750000000000002e-08 0
+ 8.7999999999999994e-08 0
+ 8.8249999999999999e-08 0
+ 8.8500000000000005e-08 0
+ 8.8749999999999997e-08 0
+ 8.9000000000000003e-08 0
+ 8.9062499999999994e-08 0
+ 8.9249999999999995e-08 0
+ 8.9500000000000001e-08 0
+ 8.9750000000000006e-08 0
+ 8.9999999999999999e-08 0
+ 9.0250000000000004e-08 0
+ 9.0499999999999996e-08 0
+ 9.0625000000000006e-08 0
+ 9.0750000000000002e-08 0
+ 9.0999999999999994e-08 0
+ 9.125e-08 0
+ 9.1500000000000005e-08 0
+ 9.1749999999999998e-08 0
+ 9.2000000000000003e-08 0
+ 9.2187500000000004e-08 0
+ 9.2249999999999996e-08 0
+ 9.2500000000000001e-08 0
+ 9.2749999999999993e-08 0
+ 9.2999999999999999e-08 0
+ 9.3250000000000005e-08 0
+ 9.3499999999999997e-08 0
+ 9.3750000000000002e-08 0
+ 9.3999999999999995e-08 0
+ 9.425e-08 0
+ 9.4500000000000006e-08 0
+ 9.4749999999999998e-08 0
+ 9.5000000000000004e-08 0
+ 9.5249999999999996e-08 0
+ 9.5312500000000001e-08 0
+ 9.5500000000000002e-08 0
+ 9.5749999999999994e-08 0
+ 9.5999999999999999e-08 0
+ 9.6250000000000005e-08 0
+ 9.6499999999999997e-08 0
+ 9.6750000000000003e-08 0
+ 9.6874999999999999e-08 0
+ 9.6999999999999995e-08 0
+ 9.7250000000000001e-08 0
+ 9.7500000000000006e-08 0
+ 9.7749999999999998e-08 0
+ 9.8000000000000004e-08 0
+ 9.8249999999999996e-08 0
+ 9.8437499999999997e-08 0
+ 9.8500000000000002e-08 0
+ 9.8749999999999994e-08 0
+ 9.9e-08 0
+ 9.9250000000000005e-08 0
+ 9.9499999999999998e-08 0
+ 9.9750000000000003e-08 0
+ 9.9999999999999995e-08 0
+ 1.0025e-07 0
+ 1.0050000000000001e-07 0
+ 1.0075e-07 0
+ 1.01e-07 0
+ 1.0125e-07 0
+ 1.015e-07 0
+ 1.0156249999999999e-07 0
+ 1.0174999999999999e-07 0
+ 1.02e-07 0
+ 1.0225000000000001e-07 0
+ 1.025e-07 0
+ 1.0275e-07 0
+ 1.03e-07 0
+ 1.0312500000000001e-07 0
+ 1.0325e-07 0
+ 1.0349999999999999e-07 0
+ 1.0375e-07 0
+ 1.04e-07 0
+ 1.0425e-07 0
+ 1.045e-07 0
+ 1.046875e-07 0
+ 1.0474999999999999e-07 0
+ 1.05e-07 0
+ 1.0525000000000001e-07 0
+ 1.055e-07 0
+ 1.0575e-07 0
+ 1.06e-07 0
+ 1.0625e-07 0
+ 1.0649999999999999e-07 0
+ 1.0675e-07 0
+ 1.0700000000000001e-07 0
+ 1.0725e-07 0
+ 1.075e-07 0
+ 1.0775e-07 0
+ 1.078125e-07 0
+ 1.08e-07 0
+ 1.0825000000000001e-07 0
+ 1.085e-07 0
+ 1.0875e-07 0
+ 1.09e-07 0
+ 1.0925e-07 0
+ 1.09375e-07 0
+ 1.0949999999999999e-07 0
+ 1.0975e-07 0
+ 1.1000000000000001e-07 0
+ 1.1025e-07 0
+ 1.105e-07 0
+ 1.1075e-07 0
+ 1.11e-07 0
+ 1.1124999999999999e-07 0
+ 1.115e-07 0
+ 1.1175e-07 0
+ 1.12e-07 0
+ 1.1225e-07 0
+ 1.1249999999999999e-07 0
+ 1.1275e-07 0
+ 1.1300000000000001e-07 0
+ 1.1325e-07 0
+ 1.135e-07 0
+ 1.1375e-07 0
+ 1.14e-07 0
+ 1.1424999999999999e-07 0
+ 1.145e-07 0
+ 1.1475000000000001e-07 0
+ 1.15e-07 0
+ 1.1525e-07 0
+ 1.155e-07 0
+ 1.1575e-07 0
+ 1.1600000000000001e-07 0
+ 1.1625e-07 0
+ 1.165e-07 0
+ 1.1675e-07 0
+ 1.17e-07 0
+ 1.1724999999999999e-07 0
+ 1.175e-07 0
+ 1.1775000000000001e-07 0
+ 1.18e-07 0
+ 1.1825e-07 0
+ 1.185e-07 0
+ 1.1875e-07 0
+ 1.1899999999999999e-07 0
+ 1.1925000000000001e-07 0
+ 1.195e-07 0
+ 1.1975e-07 0
+ 1.1999999999999999e-07 0
+ 1.2025000000000001e-07 0
+ 1.205e-07 0
+ 1.2074999999999999e-07 0
+ 1.2100000000000001e-07 0
+ 1.2125e-07 0
+ 1.215e-07 0
+ 1.2174999999999999e-07 0
+ 1.2200000000000001e-07 0
+ 1.2225e-07 0
+ 1.2249999999999999e-07 0
+ 1.2275000000000001e-07 0
+ 1.23e-07 0
+ 1.2325e-07 0
+ 1.2349999999999999e-07 0
+ 1.2375000000000001e-07 0
+ 1.24e-07 0
+ 1.2424999999999999e-07 0
+ 1.2450000000000001e-07 0
+ 1.2475e-07 0
+ 1.2499999999999999e-07 0
+ 1.2525000000000001e-07 0
+ 1.2550000000000001e-07 0
+ 1.2575e-07 0
+ 1.2599999999999999e-07 0
+ 1.2625000000000001e-07 0
+ 1.265e-07 0
+ 1.2674999999999999e-07 0
+ 1.2700000000000001e-07 0
+ 1.2725e-07 0
+ 1.275e-07 0
+ 1.2774999999999999e-07 0
+ 1.2800000000000001e-07 0
+ 1.2825e-07 0
+ 1.2849999999999999e-07 0
+ 1.2875000000000001e-07 0
+ 1.29e-07 0
+ 1.2925e-07 0
+ 1.2949999999999999e-07 0
+ 1.2975000000000001e-07 0
+ 1.3e-07 0
+ 1.3024999999999999e-07 0
+ 1.3050000000000001e-07 0
+ 1.3075e-07 0
+ 1.31e-07 0
+ 1.3124999999999999e-07 0
+ 1.3150000000000001e-07 0
+ 1.3175e-07 0
+ 1.3199999999999999e-07 0
+ 1.3225000000000001e-07 0
+ 1.325e-07 0
+ 1.3274999999999999e-07 0
+ 1.3300000000000001e-07 0
+ 1.3325000000000001e-07 0
+ 1.335e-07 0
+ 1.3374999999999999e-07 0
+ 1.3400000000000001e-07 0
+ 1.3425e-07 0
+ 1.3449999999999999e-07 0
+ 1.3475000000000001e-07 0
+ 1.35e-07 0
+ 1.3525e-07 0
+ 1.3549999999999999e-07 0
+ 1.3575000000000001e-07 0
+ 1.36e-07 0
+ 1.3624999999999999e-07 0
+ 1.3650000000000001e-07 0
+ 1.3675e-07 0
+ 1.37e-07 0
+ 1.3724999999999999e-07 0
+ 1.3750000000000001e-07 0
+ 1.3775e-07 0
+ 1.3799999999999999e-07 0
+ 1.3825000000000001e-07 0
+ 1.385e-07 0
+ 1.3875e-07 0
+ 1.3899999999999999e-07 0
+ 1.3925000000000001e-07 0
+ 1.395e-07 0
+ 1.3974999999999999e-07 0
+ 1.4000000000000001e-07 0
+ 1.4025e-07 0
+ 1.4049999999999999e-07 0
+ 1.4075000000000001e-07 0
+ 1.4100000000000001e-07 0
+ 1.4125e-07 0
+ 1.4149999999999999e-07 0
+ 1.4175000000000001e-07 0
+ 1.42e-07 0
+ 1.4224999999999999e-07 0
+ 1.4250000000000001e-07 0
+ 1.4275e-07 0
+ 1.43e-07 0
+ 1.4324999999999999e-07 0
+ 1.4350000000000001e-07 0
+ 1.4375e-07 0
+ 1.4399999999999999e-07 0
+ 1.4425000000000001e-07 0
+ 1.445e-07 0
+ 1.4475e-07 0
+ 1.4499999999999999e-07 0
+ 1.4525000000000001e-07 0
+ 1.455e-07 0
+ 1.4574999999999999e-07 0
+ 1.4600000000000001e-07 0
+ 1.4625e-07 0
+ 1.4649999999999999e-07 0
+ 1.4674999999999999e-07 0
+ 1.4700000000000001e-07 0
+ 1.4725e-07 0
+ 1.4749999999999999e-07 0
+ 1.4775000000000001e-07 0
+ 1.48e-07 0
+ 1.4824999999999999e-07 0
+ 1.4850000000000001e-07 0
+ 1.4875000000000001e-07 0
+ 1.49e-07 0
+ 1.4924999999999999e-07 0
+ 1.4950000000000001e-07 0
+ 1.4975e-07 0
+ 1.4999999999999999e-07 0
+ 1.5025000000000001e-07 0
+ 1.505e-07 0
+ 1.5075e-07 0
+ 1.5099999999999999e-07 0
+ 1.5125000000000001e-07 0
+ 1.515e-07 0
+ 1.5174999999999999e-07 0
+ 1.5200000000000001e-07 0
+ 1.5225e-07 0
+ 1.525e-07 0
+ 1.5274999999999999e-07 0
+ 1.5300000000000001e-07 0
+ 1.5325e-07 0
+ 1.5349999999999999e-07 0
+ 1.5375000000000001e-07 0
+ 1.54e-07 0
+ 1.5424999999999999e-07 0
+ 1.5449999999999999e-07 0
+ 1.5475000000000001e-07 0
+ 1.55e-07 0
+ 1.5524999999999999e-07 0
+ 1.5550000000000001e-07 0
+ 1.5575e-07 0
+ 1.5599999999999999e-07 0
+ 1.5625000000000001e-07 0
+ 1.5650000000000001e-07 0
+ 1.5675e-07 0
+ 1.5699999999999999e-07 0
+ 1.5725000000000001e-07 0
+ 1.575e-07 0
+ 1.5774999999999999e-07 0
+ 1.5800000000000001e-07 0
+ 1.5825e-07 0
+ 1.585e-07 0
+ 1.5874999999999999e-07 0
+ 1.5900000000000001e-07 0
+ 1.5925e-07 0
+ 1.5949999999999999e-07 0
+ 1.5975000000000001e-07 0
+ 1.6e-07 0
+ 1.6025e-07 0
+ 1.6049999999999999e-07 0
+ 1.6075000000000001e-07 0
+ 1.61e-07 0
+ 1.6124999999999999e-07 0
+ 1.6150000000000001e-07 0
+ 1.6175e-07 0
+ 1.6199999999999999e-07 0
+ 1.6224999999999999e-07 0
+ 1.6250000000000001e-07 0
+ 1.6275e-07 0
+ 1.6299999999999999e-07 0
+ 1.6325000000000001e-07 0
+ 1.635e-07 0
+ 1.6374999999999999e-07 0
+ 1.6400000000000001e-07 0
+ 1.6425000000000001e-07 0
+ 1.645e-07 0
+ 1.6474999999999999e-07 0
+ 1.6500000000000001e-07 0
+ 1.6525e-07 0
+ 1.6549999999999999e-07 0
+ 1.6575000000000001e-07 0
+ 1.66e-07 0
+ 1.6625e-07 0
+ 1.6649999999999999e-07 0
+ 1.6675000000000001e-07 0
+ 1.67e-07 0
+ 1.6724999999999999e-07 0
+ 1.6750000000000001e-07 0
+ 1.6775e-07 0
+ 1.68e-07 0
+ 1.6824999999999999e-07 0
+ 1.6850000000000001e-07 0
+ 1.6875e-07 0
+ 1.6899999999999999e-07 0
+ 1.6925000000000001e-07 0
+ 1.695e-07 0
+ 1.6974999999999999e-07 0
+ 1.6999999999999999e-07 0
+ 1.7025000000000001e-07 0
+ 1.705e-07 0
+ 1.7074999999999999e-07 0
+ 1.7100000000000001e-07 0
+ 1.7125e-07 0
+ 1.7149999999999999e-07 0
+ 1.7175000000000001e-07 0
+ 1.72e-07 0
+ 1.7225e-07 0
+ 1.7249999999999999e-07 0
+ 1.7275000000000001e-07 0
+ 1.73e-07 0
+ 1.7324999999999999e-07 0
+ 1.7350000000000001e-07 0
+ 1.7375e-07 0
+ 1.74e-07 0
+ 1.7424999999999999e-07 0
+ 1.7450000000000001e-07 0
+ 1.7475e-07 0
+ 1.7499999999999999e-07 0
+ 1.7525000000000001e-07 0
+ 1.755e-07 0
+ 1.7575e-07 0
+ 1.7599999999999999e-07 0
+ 1.7625000000000001e-07 0
+ 1.765e-07 0
+ 1.7674999999999999e-07 0
+ 1.7700000000000001e-07 0
+ 1.7725e-07 0
+ 1.7749999999999999e-07 0
+ 1.7774999999999999e-07 0
+ 1.7800000000000001e-07 0
+ 1.7825e-07 0
+ 1.7849999999999999e-07 0
+ 1.7875000000000001e-07 0
+ 1.79e-07 0
+ 1.7924999999999999e-07 0
+ 1.7950000000000001e-07 0
+ 1.7975e-07 0
+ 1.8e-07 0
+ 1.8024999999999999e-07 0
+ 1.8050000000000001e-07 0
+ 1.8075e-07 0
+ 1.8099999999999999e-07 0
+ 1.8125000000000001e-07 0
+ 1.815e-07 0
+ 1.8175e-07 0
+ 1.8199999999999999e-07 0
+ 1.8225000000000001e-07 0
+ 1.825e-07 0
+ 1.8274999999999999e-07 0
+ 1.8300000000000001e-07 0
+ 1.8325e-07 0
+ 1.835e-07 0
+ 1.8374999999999999e-07 0
+ 1.8400000000000001e-07 0
+ 1.8425e-07 0
+ 1.8449999999999999e-07 0
+ 1.8475000000000001e-07 0
+ 1.85e-07 0
+ 1.8524999999999999e-07 0
+ 1.8549999999999999e-07 0
+ 1.8575000000000001e-07 0
+ 1.86e-07 0
+ 1.8624999999999999e-07 0
+ 1.8650000000000001e-07 0
+ 1.8675e-07 0
+ 1.8699999999999999e-07 0
+ 1.8725000000000001e-07 0
+ 1.875e-07 0
+ 1.8775e-07 0
+ 1.8799999999999999e-07 0
+ 1.8825000000000001e-07 0
+ 1.885e-07 0
+ 1.8874999999999999e-07 0
+ 1.8900000000000001e-07 0
+ 1.8925e-07 0
+ 1.895e-07 0
+ 1.8974999999999999e-07 0
+ 1.9000000000000001e-07 0
+ 1.9025e-07 0
+ 1.9049999999999999e-07 0
+ 1.9075000000000001e-07 0
+ 1.91e-07 0
+ 1.9125e-07 0
+ 1.9149999999999999e-07 0
+ 1.9175000000000001e-07 0
+ 1.92e-07 0
+ 1.9224999999999999e-07 0
+ 1.9250000000000001e-07 0
+ 1.9275e-07 0
+ 1.9299999999999999e-07 0
+ 1.9325000000000001e-07 0
+ 1.9350000000000001e-07 0
+ 1.9375e-07 0
+ 1.9399999999999999e-07 0
+ 1.9425000000000001e-07 0
+ 1.945e-07 0
+ 1.9474999999999999e-07 0
+ 1.9500000000000001e-07 0
+ 1.9525e-07 0
+ 1.955e-07 0
+ 1.9574999999999999e-07 0
+ 1.9600000000000001e-07 0
+ 1.9625e-07 0
+ 1.9649999999999999e-07 0
+ 1.9675000000000001e-07 0
+ 1.97e-07 0
+ 1.9725e-07 0
+ 1.9749999999999999e-07 0
+ 1.9775000000000001e-07 0
+ 1.98e-07 0
+ 1.9824999999999999e-07 0
+ 1.9850000000000001e-07 0
+ 1.9875e-07 0
+ 1.99e-07 0
+ 1.9924999999999999e-07 0
+ 1.9950000000000001e-07 0
+ 1.9975e-07 0
+ 1.9999999999999999e-07 0
+ 2.0025000000000001e-07 0
+ 2.005e-07 0
+ 2.0074999999999999e-07 0
+ 2.0100000000000001e-07 0
+ 2.0125000000000001e-07 0
+ 2.015e-07 0
+ 2.0174999999999999e-07 0
+ 2.0200000000000001e-07 0
+ 2.0225e-07 0
+ 2.0249999999999999e-07 0
+ 2.0275000000000001e-07 0
+ 2.03e-07 0
+ 2.0325e-07 0
+ 2.0349999999999999e-07 0
+ 2.0375000000000001e-07 0
+ 2.04e-07 0
+ 2.0424999999999999e-07 0
+ 2.0450000000000001e-07 0
+ 2.0475e-07 0
+ 2.05e-07 0
+ 2.0524999999999999e-07 0
+ 2.0550000000000001e-07 0
+ 2.0575e-07 0
+ 2.0599999999999999e-07 0
+ 2.0625000000000001e-07 0
+ 2.065e-07 0
+ 2.0675e-07 0
+ 2.0699999999999999e-07 0
+ 2.0725000000000001e-07 0
+ 2.075e-07 0
+ 2.0774999999999999e-07 0
+ 2.0800000000000001e-07 0
+ 2.0825e-07 0
+ 2.0849999999999999e-07 0
+ 2.0875000000000001e-07 0
+ 2.0900000000000001e-07 0
+ 2.0925e-07 0
+ 2.0949999999999999e-07 0
+ 2.0975000000000001e-07 0
+ 2.1e-07 0
+ 2.1024999999999999e-07 0
+ 2.1050000000000001e-07 0
+ 2.1075e-07 0
+ 2.11e-07 0
+ 2.1124999999999999e-07 0
+ 2.1150000000000001e-07 0
+ 2.1175e-07 0
+ 2.1199999999999999e-07 0
+ 2.1225000000000001e-07 0
+ 2.125e-07 0
+ 2.1275e-07 0
+ 2.1299999999999999e-07 0
+ 2.1325000000000001e-07 0
+ 2.135e-07 0
+ 2.1374999999999999e-07 0
+ 2.1400000000000001e-07 0
+ 2.1425e-07 0
+ 2.145e-07 0
+ 2.1474999999999999e-07 0
+ 2.1500000000000001e-07 0
+ 2.1525e-07 0
+ 2.1549999999999999e-07 0
+ 2.1575000000000001e-07 0
+ 2.16e-07 0
+ 2.1624999999999999e-07 0
+ 2.1650000000000001e-07 0
+ 2.1675000000000001e-07 0
+ 2.17e-07 0
+ 2.1724999999999999e-07 0
+ 2.1750000000000001e-07 0
+ 2.1775e-07 0
+ 2.1799999999999999e-07 0
+ 2.1825000000000001e-07 0
+ 2.185e-07 0
+ 2.1875e-07 0
+ 2.1899999999999999e-07 0
+ 2.1925000000000001e-07 0
+ 2.195e-07 0
+ 2.1974999999999999e-07 0
+ 2.2000000000000001e-07 0
+ 2.2025e-07 0
+ 2.205e-07 0
+ 2.2074999999999999e-07 0
+ 2.2100000000000001e-07 0
+ 2.2125e-07 0
+ 2.2149999999999999e-07 0
+ 2.2175000000000001e-07 0
+ 2.22e-07 0
+ 2.2224999999999999e-07 0
+ 2.2249999999999999e-07 0
+ 2.2275000000000001e-07 0
+ 2.23e-07 0
+ 2.2324999999999999e-07 0
+ 2.2350000000000001e-07 0
+ 2.2375e-07 0
+ 2.2399999999999999e-07 0
+ 2.2425000000000001e-07 0
+ 2.2450000000000001e-07 0
+ 2.2475e-07 0
+ 2.2499999999999999e-07 0
+ 2.2525000000000001e-07 0
+ 2.255e-07 0
+ 2.2574999999999999e-07 0
+ 2.2600000000000001e-07 0
+ 2.2625e-07 0
+ 2.265e-07 0
+ 2.2674999999999999e-07 0
+ 2.2700000000000001e-07 0
+ 2.2725e-07 0
+ 2.2749999999999999e-07 0
+ 2.2775000000000001e-07 0
+ 2.28e-07 0
+ 2.2825e-07 0
+ 2.2849999999999999e-07 0
+ 2.2875000000000001e-07 0
+ 2.29e-07 0
+ 2.2924999999999999e-07 0
+ 2.2950000000000001e-07 0
+ 2.2975e-07 0
+ 2.2999999999999999e-07 0
+ 2.3024999999999999e-07 0
+ 2.3050000000000001e-07 0
+ 2.3075e-07 0
+ 2.3099999999999999e-07 0
+ 2.3125000000000001e-07 0
+ 2.315e-07 0
+ 2.3174999999999999e-07 0
+ 2.3200000000000001e-07 0
+ 2.3225000000000001e-07 0
+ 2.325e-07 0
+ 2.3274999999999999e-07 0
+ 2.3300000000000001e-07 0
+ 2.3325e-07 0
+ 2.3349999999999999e-07 0
+ 2.3375000000000001e-07 0
+ 2.34e-07 0
+ 2.3425e-07 0
+ 2.3449999999999999e-07 0
+ 2.3475000000000001e-07 0
+ 2.35e-07 0
+ 2.3524999999999999e-07 0
+ 2.3550000000000001e-07 0
+ 2.3575e-07 0
+ 2.36e-07 0
+ 2.3624999999999999e-07 0
+ 2.3650000000000001e-07 0
+ 2.3675e-07 0
+ 2.3699999999999999e-07 0
+ 2.3725000000000001e-07 0
+ 2.375e-07 0
+ 2.3774999999999999e-07 0
+ 2.3799999999999999e-07 0
+ 2.3825000000000001e-07 0
+ 2.3850000000000002e-07 0
+ 2.3874999999999999e-07 0
+ 2.3900000000000001e-07 0
+ 2.3924999999999998e-07 0
+ 2.3949999999999999e-07 0
+ 2.3975000000000001e-07 0
+ 2.3999999999999998e-07 0
+ 2.4025e-07 0
+ 2.4050000000000002e-07 0
+ 2.4074999999999998e-07 0
+ 2.41e-07 0
+ 2.4125000000000002e-07 0
+ 2.4149999999999999e-07 0
+ 2.4175e-07 0
+ 2.4200000000000002e-07 0
+ 2.4224999999999999e-07 0
+ 2.4250000000000001e-07 0
+ 2.4275000000000003e-07 0
+ 2.4299999999999999e-07 0
+ 2.4325000000000001e-07 0
+ 2.4349999999999998e-07 0
+ 2.4375e-07 0
+ 2.4400000000000001e-07 0
+ 2.4424999999999998e-07 0
+ 2.445e-07 0
+ 2.4475000000000002e-07 0
+ 2.4499999999999998e-07 0
+ 2.4525e-07 0
+ 2.4550000000000002e-07 0
+ 2.4574999999999999e-07 0
+ 2.4600000000000001e-07 0
+ 2.4625000000000002e-07 0
+ 2.4649999999999999e-07 0
+ 2.4675000000000001e-07 0
+ 2.4699999999999998e-07 0
+ 2.4724999999999999e-07 0
+ 2.4750000000000001e-07 0
+ 2.4774999999999998e-07 0
+ 2.48e-07 0
+ 2.4825000000000002e-07 0
+ 2.4849999999999998e-07 0
+ 2.4875e-07 0
+ 2.4900000000000002e-07 0
+ 2.4924999999999999e-07 0
+ 2.495e-07 0
+ 2.4975000000000002e-07 0
+ 2.4999999999999999e-07 0
+ 2.5025000000000001e-07 0
+ 2.5050000000000003e-07 0
+ 2.5074999999999999e-07 0
+ 2.5100000000000001e-07 0
+ 2.5124999999999998e-07 0
+ 2.515e-07 0
+ 2.5175000000000001e-07 0
+ 2.5199999999999998e-07 0
+ 2.5225e-07 0
+ 2.5250000000000002e-07 0
+ 2.5274999999999998e-07 0
+ 2.53e-07 0
+ 2.5325000000000002e-07 0
+ 2.5349999999999999e-07 0
+ 2.5375000000000001e-07 0
+ 2.5400000000000002e-07 0
+ 2.5424999999999999e-07 0
+ 2.5450000000000001e-07 0
+ 2.5474999999999997e-07 0
+ 2.5499999999999999e-07 0
+ 2.5525000000000001e-07 0
+ 2.5549999999999998e-07 0
+ 2.5575e-07 0
+ 2.5600000000000002e-07 0
+ 2.5624999999999998e-07 0
+ 2.565e-07 0
+ 2.5675000000000002e-07 0
+ 2.5699999999999999e-07 0
+ 2.5725e-07 0
+ 2.5750000000000002e-07 0
+ 2.5774999999999999e-07 0
+ 2.5800000000000001e-07 0
+ 2.5825000000000003e-07 0
+ 2.5849999999999999e-07 0
+ 2.5875000000000001e-07 0
+ 2.5899999999999998e-07 0
+ 2.5925e-07 0
+ 2.5950000000000001e-07 0
+ 2.5974999999999998e-07 0
+ 2.6e-07 0
+ 2.6025000000000002e-07 0
+ 2.6049999999999998e-07 0
+ 2.6075e-07 0
+ 2.6100000000000002e-07 0
+ 2.6124999999999999e-07 0
+ 2.6150000000000001e-07 0
+ 2.6175000000000002e-07 0
+ 2.6199999999999999e-07 0
+ 2.6225000000000001e-07 0
+ 2.6249999999999997e-07 0
+ 2.6274999999999999e-07 0
+ 2.6300000000000001e-07 0
+ 2.6324999999999998e-07 0
+ 2.635e-07 0
+ 2.6375000000000002e-07 0
+ 2.6399999999999998e-07 0
+ 2.6425e-07 0
+ 2.6450000000000002e-07 0
+ 2.6474999999999999e-07 0
+ 2.65e-07 0
+ 2.6525000000000002e-07 0
+ 2.6549999999999999e-07 0
+ 2.6575000000000001e-07 0
+ 2.6600000000000003e-07 0
+ 2.6624999999999999e-07 0
+ 2.6650000000000001e-07 0
+ 2.6674999999999998e-07 0
+ 2.67e-07 0
+ 2.6725000000000001e-07 0
+ 2.6749999999999998e-07 0
+ 2.6775e-07 0
+ 2.6800000000000002e-07 0
+ 2.6824999999999998e-07 0
+ 2.685e-07 0
+ 2.6875000000000002e-07 0
+ 2.6899999999999999e-07 0
+ 2.6925000000000001e-07 0
+ 2.6950000000000002e-07 0
+ 2.6974999999999999e-07 0
+ 2.7000000000000001e-07 0
+ 2.7024999999999997e-07 0
+ 2.7049999999999999e-07 0
+ 2.7075000000000001e-07 0
+ 2.7099999999999998e-07 0
+ 2.7125e-07 0
+ 2.7150000000000002e-07 0
+ 2.7174999999999998e-07 0
+ 2.72e-07 0
+ 2.7225000000000002e-07 0
+ 2.7249999999999999e-07 0
+ 2.7275e-07 0
+ 2.7300000000000002e-07 0
+ 2.7324999999999999e-07 0
+ 2.7350000000000001e-07 0
+ 2.7375000000000003e-07 0
+ 2.7399999999999999e-07 0
+ 2.7425000000000001e-07 0
+ 2.7449999999999998e-07 0
+ 2.7475e-07 0
+ 2.7500000000000001e-07 0
+ 2.7524999999999998e-07 0
+ 2.755e-07 0
+ 2.7575000000000002e-07 0
+ 2.7599999999999998e-07 0
+ 2.7625e-07 0
+ 2.7650000000000002e-07 0
+ 2.7674999999999999e-07 0
+ 2.7700000000000001e-07 0
+ 2.7725000000000002e-07 0
+ 2.7749999999999999e-07 0
+ 2.7775000000000001e-07 0
+ 2.7799999999999997e-07 0
+ 2.7824999999999999e-07 0
+ 2.7850000000000001e-07 0
+ 2.7874999999999998e-07 0
+ 2.79e-07 0
+ 2.7925000000000002e-07 0
+ 2.7949999999999998e-07 0
+ 2.7975e-07 0
+ 2.8000000000000002e-07 0
+ 2.8024999999999998e-07 0
+ 2.805e-07 0
+ 2.8075000000000002e-07 0
+ 2.8099999999999999e-07 0
+ 2.8125000000000001e-07 0
+ 2.8150000000000003e-07 0
+ 2.8174999999999999e-07 0
+ 2.8200000000000001e-07 0
+ 2.8224999999999998e-07 0
+ 2.825e-07 0
+ 2.8275000000000001e-07 0
+ 2.8299999999999998e-07 0
+ 2.8325e-07 0
+ 2.8350000000000002e-07 0
+ 2.8374999999999998e-07 0
+ 2.84e-07 0
+ 2.8425000000000002e-07 0
+ 2.8449999999999999e-07 0
+ 2.8475000000000001e-07 0
+ 2.8500000000000002e-07 0
+ 2.8524999999999999e-07 0
+ 2.8550000000000001e-07 0
+ 2.8574999999999997e-07 0
+ 2.8599999999999999e-07 0
+ 2.8625000000000001e-07 0
+ 2.8649999999999998e-07 0
+ 2.8675e-07 0
+ 2.8700000000000002e-07 0
+ 2.8724999999999998e-07 0
+ 2.875e-07 0
+ 2.8775000000000002e-07 0
+ 2.8799999999999998e-07 0
+ 2.8825e-07 0
+ 2.8850000000000002e-07 0
+ 2.8874999999999999e-07 0
+ 2.8900000000000001e-07 0
+ 2.8925000000000003e-07 0
+ 2.8949999999999999e-07 0
+ 2.8975000000000001e-07 0
+ 2.8999999999999998e-07 0
+ 2.9025e-07 0
+ 2.9050000000000001e-07 0
+ 2.9074999999999998e-07 0
+ 2.91e-07 0
+ 2.9125000000000002e-07 0
+ 2.9149999999999998e-07 0
+ 2.9175e-07 0
+ 2.9200000000000002e-07 0
+ 2.9224999999999999e-07 0
+ 2.9250000000000001e-07 0
+ 2.9275000000000002e-07 0
+ 2.9299999999999999e-07 0
+ 2.9325000000000001e-07 0
+ 2.9349999999999997e-07 0
+ 2.9374999999999999e-07 0
+ 2.9400000000000001e-07 0
+ 2.9424999999999998e-07 0
+ 2.945e-07 0
+ 2.9475000000000002e-07 0
+ 2.9499999999999998e-07 0
+ 2.9525e-07 0
+ 2.9550000000000002e-07 0
+ 2.9574999999999998e-07 0
+ 2.96e-07 0
+ 2.9625000000000002e-07 0
+ 2.9649999999999999e-07 0
+ 2.9675000000000001e-07 0
+ 2.9700000000000003e-07 0
+ 2.9724999999999999e-07 0
+ 2.9750000000000001e-07 0
+ 2.9774999999999998e-07 0
+ 2.9799999999999999e-07 0
+ 2.9825000000000001e-07 0
+ 2.9849999999999998e-07 0
+ 2.9875e-07 0
+ 2.9900000000000002e-07 0
+ 2.9924999999999998e-07 0
+ 2.995e-07 0
+ 2.9975000000000002e-07 0
+ 2.9999999999999999e-07 0
+ 3.0025000000000001e-07 0
+ 3.0050000000000002e-07 0
+ 3.0074999999999999e-07 0
+ 3.0100000000000001e-07 0
+ 3.0124999999999997e-07 0
+ 3.0149999999999999e-07 0
+ 3.0175000000000001e-07 0
+ 3.0199999999999998e-07 0
+ 3.0225e-07 0
+ 3.0250000000000002e-07 0
+ 3.0274999999999998e-07 0
+ 3.03e-07 0
+ 3.0325000000000002e-07 0
+ 3.0349999999999998e-07 0
+ 3.0375e-07 0
+ 3.0400000000000002e-07 0
+ 3.0424999999999999e-07 0
+ 3.0450000000000001e-07 0
+ 3.0475000000000003e-07 0
+ 3.0499999999999999e-07 0
+ 3.0525000000000001e-07 0
+ 3.0549999999999998e-07 0
+ 3.0574999999999999e-07 0
+ 3.0600000000000001e-07 0
+ 3.0624999999999998e-07 0
+ 3.065e-07 0
+ 3.0675000000000002e-07 0
+ 3.0699999999999998e-07 0
+ 3.0725e-07 0
+ 3.0750000000000002e-07 0
+ 3.0774999999999999e-07 0
+ 3.0800000000000001e-07 0
+ 3.0825000000000002e-07 0
+ 3.0849999999999999e-07 0
+ 3.0875000000000001e-07 0
+ 3.0899999999999997e-07 0
+ 3.0924999999999999e-07 0
+ 3.0950000000000001e-07 0
+ 3.0974999999999998e-07 0
+ 3.1e-07 0
+ 3.1025000000000002e-07 0
+ 3.1049999999999998e-07 0
+ 3.1075e-07 0
+ 3.1100000000000002e-07 0
+ 3.1124999999999998e-07 0
+ 3.115e-07 0
+ 3.1175000000000002e-07 0
+ 3.1199999999999999e-07 0
+ 3.1225000000000001e-07 0
+ 3.1250000000000003e-07 0
+ 3.1274999999999999e-07 0
+ 3.1300000000000001e-07 0
+ 3.1324999999999998e-07 0
+ 3.1349999999999999e-07 0
+ 3.1375000000000001e-07 0
+ 3.1399999999999998e-07 0
+ 3.1425e-07 0
+ 3.1450000000000002e-07 0
+ 3.1474999999999998e-07 0
+ 3.15e-07 0
+ 3.1525000000000002e-07 0
+ 3.1549999999999999e-07 0
+ 3.1575000000000001e-07 0
+ 3.1600000000000002e-07 0
+ 3.1624999999999999e-07 0
+ 3.1650000000000001e-07 0
+ 3.1674999999999997e-07 0
+ 3.1699999999999999e-07 0
+ 3.1725000000000001e-07 0
+ 3.1749999999999998e-07 0
+ 3.1775e-07 0
+ 3.1800000000000002e-07 0
+ 3.1824999999999998e-07 0
+ 3.185e-07 0
+ 3.1875000000000002e-07 0
+ 3.1899999999999998e-07 0
+ 3.1925e-07 0
+ 3.1950000000000002e-07 0
+ 3.1974999999999999e-07 0
+ 3.2000000000000001e-07 0
+ 3.2025000000000003e-07 0
+ 3.2049999999999999e-07 0
+ 3.2075000000000001e-07 0
+ 3.2099999999999998e-07 0
+ 3.2124999999999999e-07 0
+ 3.2150000000000001e-07 0
+ 3.2174999999999998e-07 0
+ 3.22e-07 0
+ 3.2225000000000002e-07 0
+ 3.2249999999999998e-07 0
+ 3.2275e-07 0
+ 3.2300000000000002e-07 0
+ 3.2324999999999999e-07 0
+ 3.235e-07 0
+ 3.2375000000000002e-07 0
+ 3.2399999999999999e-07 0
+ 3.2425000000000001e-07 0
+ 3.2449999999999997e-07 0
+ 3.2474999999999999e-07 0
+ 3.2500000000000001e-07 0
+ 3.2524999999999998e-07 0
+ 3.255e-07 0
+ 3.2575000000000002e-07 0
+ 3.2599999999999998e-07 0
+ 3.2625e-07 0
+ 3.2650000000000002e-07 0
+ 3.2674999999999998e-07 0
+ 3.27e-07 0
+ 3.2725000000000002e-07 0
+ 3.2749999999999999e-07 0
+ 3.2775000000000001e-07 0
+ 3.2800000000000003e-07 0
+ 3.2824999999999999e-07 0
+ 3.2850000000000001e-07 0
+ 3.2874999999999998e-07 0
+ 3.2899999999999999e-07 0
+ 3.2925000000000001e-07 0
+ 3.2949999999999998e-07 0
+ 3.2975e-07 0
+ 3.3000000000000002e-07 0
+ 3.3024999999999998e-07 0
+ 3.305e-07 0
+ 3.3075000000000002e-07 0
+ 3.3099999999999999e-07 0
+ 3.3125e-07 0
+ 3.3150000000000002e-07 0
+ 3.3174999999999999e-07 0
+ 3.3200000000000001e-07 0
+ 3.3224999999999997e-07 0
+ 3.3249999999999999e-07 0
+ 3.3275000000000001e-07 0
+ 3.3299999999999998e-07 0
+ 3.3325e-07 0
+ 3.3350000000000002e-07 0
+ 3.3374999999999998e-07 0
+ 3.34e-07 0
+ 3.3425000000000002e-07 0
+ 3.3449999999999998e-07 0
+ 3.3475e-07 0
+ 3.3500000000000002e-07 0
+ 3.3524999999999999e-07 0
+ 3.3550000000000001e-07 0
+ 3.3575000000000003e-07 0
+ 3.3599999999999999e-07 0
+ 3.3625000000000001e-07 0
+ 3.3649999999999998e-07 0
+ 3.3674999999999999e-07 0
+ 3.3700000000000001e-07 0
+ 3.3724999999999998e-07 0
+ 3.375e-07 0
+ 3.3775000000000002e-07 0
+ 3.3799999999999998e-07 0
+ 3.3825e-07 0
+ 3.3850000000000002e-07 0
+ 3.3874999999999999e-07 0
+ 3.39e-07 0
+ 3.3925000000000002e-07 0
+ 3.3949999999999999e-07 0
+ 3.3975000000000001e-07 0
+ 3.3999999999999997e-07 0
+ 3.4024999999999999e-07 0
+ 3.4050000000000001e-07 0
+ 3.4074999999999998e-07 0
+ 3.41e-07 0
+ 3.4125000000000001e-07 0
+ 3.4149999999999998e-07 0
+ 3.4175e-07 0
+ 3.4200000000000002e-07 0
+ 3.4224999999999998e-07 0
+ 3.425e-07 0
+ 3.4275000000000002e-07 0
+ 3.4299999999999999e-07 0
+ 3.4325000000000001e-07 0
+ 3.4350000000000003e-07 0
+ 3.4374999999999999e-07 0
+ 3.4400000000000001e-07 0
+ 3.4424999999999998e-07 0
+ 3.4449999999999999e-07 0
+ 3.4475000000000001e-07 0
+ 3.4499999999999998e-07 0
+ 3.4525e-07 0
+ 3.4550000000000002e-07 0
+ 3.4574999999999998e-07 0
+ 3.46e-07 0
+ 3.4625000000000002e-07 0
+ 3.4649999999999999e-07 0
+ 3.4675e-07 0
+ 3.4700000000000002e-07 0
+ 3.4724999999999999e-07 0
+ 3.4750000000000001e-07 0
+ 3.4774999999999997e-07 0
+ 3.4799999999999999e-07 0
+ 3.4825000000000001e-07 0
+ 3.4849999999999998e-07 0
+ 3.4875e-07 0
+ 3.4900000000000001e-07 0
+ 3.4924999999999998e-07 0
+ 3.495e-07 0
+ 3.4975000000000002e-07 0
+ 3.4999999999999998e-07 0
+ 3.5025e-07 0
+ 3.5050000000000002e-07 0
+ 3.5074999999999999e-07 0
+ 3.5100000000000001e-07 0
+ 3.5125000000000003e-07 0
+ 3.5149999999999999e-07 0
+ 3.5175000000000001e-07 0
+ 3.5199999999999998e-07 0
+ 3.5224999999999999e-07 0
+ 3.5250000000000001e-07 0
+ 3.5274999999999998e-07 0
+ 3.53e-07 0
+ 3.5325000000000002e-07 0
+ 3.5349999999999998e-07 0
+ 3.5375e-07 0
+ 3.5400000000000002e-07 0
+ 3.5424999999999999e-07 0
+ 3.545e-07 0
+ 3.5475000000000002e-07 0
+ 3.5499999999999999e-07 0
+ 3.5525000000000001e-07 0
+ 3.5549999999999997e-07 0
+ 3.5574999999999999e-07 0
+ 3.5600000000000001e-07 0
+ 3.5624999999999998e-07 0
+ 3.565e-07 0
+ 3.5675000000000001e-07 0
+ 3.5699999999999998e-07 0
+ 3.5725e-07 0
+ 3.5750000000000002e-07 0
+ 3.5774999999999998e-07 0
+ 3.58e-07 0
+ 3.5825000000000002e-07 0
+ 3.5849999999999999e-07 0
+ 3.5875000000000001e-07 0
+ 3.5900000000000003e-07 0
+ 3.5924999999999999e-07 0
+ 3.5950000000000001e-07 0
+ 3.5974999999999998e-07 0
+ 3.5999999999999999e-07 0
+ 3.6025000000000001e-07 0
+ 3.6049999999999998e-07 0
+ 3.6075e-07 0
+ 3.6100000000000002e-07 0
+ 3.6124999999999998e-07 0
+ 3.615e-07 0
+ 3.6175000000000002e-07 0
+ 3.6199999999999999e-07 0
+ 3.6225e-07 0
+ 3.6250000000000002e-07 0
+ 3.6274999999999999e-07 0
+ 3.6300000000000001e-07 0
+ 3.6324999999999997e-07 0
+ 3.6349999999999999e-07 0
+ 3.6375000000000001e-07 0
+ 3.6399999999999998e-07 0
+ 3.6425e-07 0
+ 3.6450000000000001e-07 0
+ 3.6474999999999998e-07 0
+ 3.65e-07 0
+ 3.6525000000000002e-07 0
+ 3.6549999999999998e-07 0
+ 3.6575e-07 0
+ 3.6600000000000002e-07 0
+ 3.6624999999999999e-07 0
+ 3.6650000000000001e-07 0
+ 3.6675000000000002e-07 0
+ 3.6699999999999999e-07 0
+ 3.6725000000000001e-07 0
+ 3.6749999999999998e-07 0
+ 3.6774999999999999e-07 0
+ 3.6800000000000001e-07 0
+ 3.6824999999999998e-07 0
+ 3.685e-07 0
+ 3.6875000000000002e-07 0
+ 3.6899999999999998e-07 0
+ 3.6925e-07 0
+ 3.6950000000000002e-07 0
+ 3.6974999999999999e-07 0
+ 3.7e-07 0
+ 3.7025000000000002e-07 0
+ 3.7049999999999999e-07 0
+ 3.7075000000000001e-07 0
+ 3.7099999999999997e-07 0
+ 3.7124999999999999e-07 0
+ 3.7150000000000001e-07 0
+ 3.7174999999999998e-07 0
+ 3.72e-07 0
+ 3.7225000000000001e-07 0
+ 3.7249999999999998e-07 0
+ 3.7275e-07 0
+ 3.7300000000000002e-07 0
+ 3.7324999999999998e-07 0
+ 3.735e-07 0
+ 3.7375000000000002e-07 0
+ 3.7399999999999999e-07 0
+ 3.7425000000000001e-07 0
+ 3.7450000000000002e-07 0
+ 3.7474999999999999e-07 0
+ 3.7500000000000001e-07 0
+ 3.7524999999999998e-07 0
+ 3.7549999999999999e-07 0
+ 3.7575000000000001e-07 0
+ 3.7599999999999998e-07 0
+ 3.7625e-07 0
+ 3.7650000000000002e-07 0
+ 3.7674999999999998e-07 0
+ 3.77e-07 0
+ 3.7725000000000002e-07 0
+ 3.7749999999999999e-07 0
+ 3.7775e-07 0
+ 3.7800000000000002e-07 0
+ 3.7824999999999999e-07 0
+ 3.7850000000000001e-07 0
+ 3.7874999999999997e-07 0
+ 3.7899999999999999e-07 0
+ 3.7925000000000001e-07 0
+ 3.7949999999999998e-07 0
+ 3.7975e-07 0
+ 3.8000000000000001e-07 0
+ 3.8024999999999998e-07 0
+ 3.805e-07 0
+ 3.8075000000000002e-07 0
+ 3.8099999999999998e-07 0
+ 3.8125e-07 0
+ 3.8150000000000002e-07 0
+ 3.8174999999999999e-07 0
+ 3.8200000000000001e-07 0
+ 3.8225000000000002e-07 0
+ 3.8249999999999999e-07 0
+ 3.8275000000000001e-07 0
+ 3.8299999999999998e-07 0
+ 3.8324999999999999e-07 0
+ 3.8350000000000001e-07 0
+ 3.8374999999999998e-07 0
+ 3.84e-07 0
+ 3.8425000000000002e-07 0
+ 3.8449999999999998e-07 0
+ 3.8475e-07 0
+ 3.8500000000000002e-07 0
+ 3.8524999999999999e-07 0
+ 3.855e-07 0
+ 3.8575000000000002e-07 0
+ 3.8599999999999999e-07 0
+ 3.8625000000000001e-07 0
+ 3.8650000000000003e-07 0
+ 3.8674999999999999e-07 0
+ 3.8700000000000001e-07 0
+ 3.8724999999999998e-07 0
+ 3.875e-07 0
+ 3.8775000000000001e-07 0
+ 3.8799999999999998e-07 0
+ 3.8825e-07 0
+ 3.8850000000000002e-07 0
+ 3.8874999999999998e-07 0
+ 3.89e-07 0
+ 3.8925000000000002e-07 0
+ 3.8949999999999999e-07 0
+ 3.8975000000000001e-07 0
+ 3.9000000000000002e-07 0
+ 3.9024999999999999e-07 0
+ 3.9050000000000001e-07 0
+ 3.9074999999999998e-07 0
+ 3.9099999999999999e-07 0
+ 3.9125000000000001e-07 0
+ 3.9149999999999998e-07 0
+ 3.9175e-07 0
+ 3.9200000000000002e-07 0
+ 3.9224999999999998e-07 0
+ 3.925e-07 0
+ 3.9275000000000002e-07 0
+ 3.9299999999999999e-07 0
+ 3.9325e-07 0
+ 3.9350000000000002e-07 0
+ 3.9374999999999999e-07 0
+ 3.9400000000000001e-07 0
+ 3.9425000000000003e-07 0
+ 3.9449999999999999e-07 0
+ 3.9475000000000001e-07 0
+ 3.9499999999999998e-07 0
+ 3.9525e-07 0
+ 3.9550000000000001e-07 0
+ 3.9574999999999998e-07 0
+ 3.96e-07 0
+ 3.9625000000000002e-07 0
+ 3.9649999999999998e-07 0
+ 3.9675e-07 0
+ 3.9700000000000002e-07 0
+ 3.9724999999999999e-07 0
+ 3.9750000000000001e-07 0
+ 3.9775000000000002e-07 0
+ 3.9799999999999999e-07 0
+ 3.9825000000000001e-07 0
+ 3.9849999999999998e-07 0
+ 3.9874999999999999e-07 0
+ 3.9900000000000001e-07 0
+ 3.9924999999999998e-07 0
+ 3.995e-07 0
+ 3.9975000000000002e-07 0
+ 3.9999999999999998e-07 0
+ 4.0025e-07 0
+ 4.0050000000000002e-07 0
+ 4.0074999999999999e-07 0
+ 4.01e-07 0
+ 4.0125000000000002e-07 0
+ 4.0149999999999999e-07 0
+ 4.0175000000000001e-07 0
+ 4.0200000000000003e-07 0
+ 4.0224999999999999e-07 0
+ 4.0250000000000001e-07 0
+ 4.0274999999999998e-07 0
+ 4.03e-07 0
+ 4.0325000000000001e-07 0
+ 4.0349999999999998e-07 0
+ 4.0375e-07 0
+ 4.0400000000000002e-07 0
+ 4.0424999999999998e-07 0
+ 4.045e-07 0
+ 4.0475000000000002e-07 0
+ 4.0499999999999999e-07 0
+ 4.0525000000000001e-07 0
+ 4.0550000000000002e-07 0
+ 4.0574999999999999e-07 0
+ 4.0600000000000001e-07 0
+ 4.0624999999999997e-07 0
+ 4.0649999999999999e-07 0
+ 4.0675000000000001e-07 0
+ 4.0699999999999998e-07 0
+ 4.0725e-07 0
+ 4.0750000000000002e-07 0
+ 4.0774999999999998e-07 0
+ 4.08e-07 0
+ 4.0825000000000002e-07 0
+ 4.0849999999999999e-07 0
+ 4.0875e-07 0
+ 4.0900000000000002e-07 0
+ 4.0924999999999999e-07 0
+ 4.0950000000000001e-07 0
+ 4.0975000000000003e-07 0
+ 4.0999999999999999e-07 0
+ 4.1025000000000001e-07 0
+ 4.1049999999999998e-07 0
+ 4.1075e-07 0
+ 4.1100000000000001e-07 0
+ 4.1124999999999998e-07 0
+ 4.115e-07 0
+ 4.1175000000000002e-07 0
+ 4.1199999999999998e-07 0
+ 4.1225e-07 0
+ 4.1250000000000002e-07 0
+ 4.1274999999999999e-07 0
+ 4.1300000000000001e-07 0
+ 4.1325000000000002e-07 0
+ 4.1349999999999999e-07 0
+ 4.1375000000000001e-07 0
+ 4.1399999999999997e-07 0
+ 4.1424999999999999e-07 0
+ 4.1450000000000001e-07 0
+ 4.1474999999999998e-07 0
+ 4.15e-07 0
+ 4.1525000000000002e-07 0
+ 4.1549999999999998e-07 0
+ 4.1575e-07 0
+ 4.1600000000000002e-07 0
+ 4.1624999999999999e-07 0
+ 4.165e-07 0
+ 4.1675000000000002e-07 0
+ 4.1699999999999999e-07 0
+ 4.1725000000000001e-07 0
+ 4.1750000000000003e-07 0
+ 4.1774999999999999e-07 0
+ 4.1800000000000001e-07 0
+ 4.1824999999999998e-07 0
+ 4.185e-07 0
+ 4.1875000000000001e-07 0
+ 4.1899999999999998e-07 0
+ 4.1925e-07 0
+ 4.1950000000000002e-07 0
+ 4.1974999999999998e-07 0
+ 4.2e-07 0
+ 4.2025000000000002e-07 0
+ 4.2049999999999999e-07 0
+ 4.2075000000000001e-07 0
+ 4.2100000000000002e-07 0
+ 4.2124999999999999e-07 0
+ 4.2150000000000001e-07 0
+ 4.2174999999999997e-07 0
+ 4.2199999999999999e-07 0
+ 4.2225000000000001e-07 0
+ 4.2249999999999998e-07 0
+ 4.2275e-07 0
+ 4.2300000000000002e-07 0
+ 4.2324999999999998e-07 0
+ 4.235e-07 0
+ 4.2375000000000002e-07 0
+ 4.2399999999999999e-07 0
+ 4.2425e-07 0
+ 4.2450000000000002e-07 0
+ 4.2474999999999999e-07 0
+ 4.2500000000000001e-07 0
+ 4.2525000000000003e-07 0
+ 4.2549999999999999e-07 0
+ 4.2575000000000001e-07 0
+ 4.2599999999999998e-07 0
+ 4.2625e-07 0
+ 4.2650000000000001e-07 0
+ 4.2674999999999998e-07 0
+ 4.27e-07 0
+ 4.2725000000000002e-07 0
+ 4.2749999999999998e-07 0
+ 4.2775e-07 0
+ 4.2800000000000002e-07 0
+ 4.2824999999999999e-07 0
+ 4.2850000000000001e-07 0
+ 4.2875000000000002e-07 0
+ 4.2899999999999999e-07 0
+ 4.2925000000000001e-07 0
+ 4.2949999999999997e-07 0
+ 4.2974999999999999e-07 0
+ 4.3000000000000001e-07 0
+ 4.3024999999999998e-07 0
+ 4.305e-07 0
+ 4.3075000000000002e-07 0
+ 4.3099999999999998e-07 0
+ 4.3125e-07 0
+ 4.3150000000000002e-07 0
+ 4.3174999999999998e-07 0
+ 4.32e-07 0
+ 4.3225000000000002e-07 0
+ 4.3249999999999999e-07 0
+ 4.3275000000000001e-07 0
+ 4.3300000000000003e-07 0
+ 4.3324999999999999e-07 0
+ 4.3350000000000001e-07 0
+ 4.3374999999999998e-07 0
+ 4.34e-07 0
+ 4.3425000000000001e-07 0
+ 4.3449999999999998e-07 0
+ 4.3475e-07 0
+ 4.3500000000000002e-07 0
+ 4.3524999999999998e-07 0
+ 4.355e-07 0
+ 4.3575000000000002e-07 0
+ 4.3599999999999999e-07 0
+ 4.3625000000000001e-07 0
+ 4.3650000000000002e-07 0
+ 4.3674999999999999e-07 0
+ 4.3700000000000001e-07 0
+ 4.3724999999999997e-07 0
+ 4.3749999999999999e-07 0
+ 4.3775000000000001e-07 0
+ 4.3799999999999998e-07 0
+ 4.3825e-07 0
+ 4.3850000000000002e-07 0
+ 4.3874999999999998e-07 0
+ 4.39e-07 0
+ 4.3925000000000002e-07 0
+ 4.3949999999999998e-07 0
+ 4.3975e-07 0
+ 4.4000000000000002e-07 0
+ 4.4024999999999999e-07 0
+ 4.4050000000000001e-07 0
+ 4.4075000000000003e-07 0
+ 4.4099999999999999e-07 0
+ 4.4125000000000001e-07 0
+ 4.4149999999999998e-07 0
+ 4.4175e-07 0
+ 4.4200000000000001e-07 0
+ 4.4224999999999998e-07 0
+ 4.425e-07 0
+ 4.4275000000000002e-07 0
+ 4.4299999999999998e-07 0
+ 4.4325e-07 0
+ 4.4350000000000002e-07 0
+ 4.4374999999999999e-07 0
+ 4.4400000000000001e-07 0
+ 4.4425000000000002e-07 0
+ 4.4449999999999999e-07 0
+ 4.4475000000000001e-07 0
+ 4.4499999999999997e-07 0
+ 4.4524999999999999e-07 0
+ 4.4550000000000001e-07 0
+ 4.4574999999999998e-07 0
+ 4.46e-07 0
+ 4.4625000000000002e-07 0
+ 4.4649999999999998e-07 0
+ 4.4675e-07 0
+ 4.4700000000000002e-07 0
+ 4.4724999999999998e-07 0
+ 4.475e-07 0
+ 4.4775000000000002e-07 0
+ 4.4799999999999999e-07 0
+ 4.4825000000000001e-07 0
+ 4.4850000000000003e-07 0
+ 4.4874999999999999e-07 0
+ 4.4900000000000001e-07 0
+ 4.4924999999999998e-07 0
+ 4.495e-07 0
+ 4.4975000000000001e-07 0
+ 4.4999999999999998e-07 0
+ 4.5025e-07 0
+ 4.5050000000000002e-07 0
+ 4.5074999999999998e-07 0
+ 4.51e-07 0
+ 4.5125000000000002e-07 0
+ 4.5149999999999999e-07 0
+ 4.5175000000000001e-07 0
+ 4.5200000000000002e-07 0
+ 4.5224999999999999e-07 0
+ 4.5250000000000001e-07 0
+ 4.5274999999999997e-07 0
+ 4.5299999999999999e-07 0
+ 4.5325000000000001e-07 0
+ 4.5349999999999998e-07 0
+ 4.5375e-07 0
+ 4.5400000000000002e-07 0
+ 4.5424999999999998e-07 0
+ 4.545e-07 0
+ 4.5475000000000002e-07 0
+ 4.5499999999999998e-07 0
+ 4.5525e-07 0
+ 4.5550000000000002e-07 0
+ 4.5574999999999999e-07 0
+ 4.5600000000000001e-07 0
+ 4.5625000000000003e-07 0
+ 4.5649999999999999e-07 0
+ 4.5675000000000001e-07 0
+ 4.5699999999999998e-07 0
+ 4.5724999999999999e-07 0
+ 4.5750000000000001e-07 0
+ 4.5774999999999998e-07 0
+ 4.58e-07 0
+ 4.5825000000000002e-07 0
+ 4.5849999999999998e-07 0
+ 4.5875e-07 0
+ 4.5900000000000002e-07 0
+ 4.5924999999999999e-07 0
+ 4.5950000000000001e-07 0
+ 4.5975000000000002e-07 0
+ 4.5999999999999999e-07 0
+ 4.6025000000000001e-07 0
+ 4.6049999999999997e-07 0
+ 4.6074999999999999e-07 0
+ 4.6100000000000001e-07 0
+ 4.6124999999999998e-07 0
+ 4.615e-07 0
+ 4.6175000000000002e-07 0
+ 4.6199999999999998e-07 0
+ 4.6225e-07 0
+ 4.6250000000000002e-07 0
+ 4.6274999999999998e-07 0
+ 4.63e-07 0
+ 4.6325000000000002e-07 0
+ 4.6349999999999999e-07 0
+ 4.6375000000000001e-07 0
+ 4.6400000000000003e-07 0
+ 4.6424999999999999e-07 0
+ 4.6450000000000001e-07 0
+ 4.6474999999999998e-07 0
+ 4.6499999999999999e-07 0
+ 4.6525000000000001e-07 0
+ 4.6549999999999998e-07 0
+ 4.6575e-07 0
+ 4.6600000000000002e-07 0
+ 4.6624999999999998e-07 0
+ 4.665e-07 0
+ 4.6675000000000002e-07 0
+ 4.6699999999999999e-07 0
+ 4.6725000000000001e-07 0
+ 4.6750000000000002e-07 0
+ 4.6774999999999999e-07 0
+ 4.6800000000000001e-07 0
+ 4.6824999999999997e-07 0
+ 4.6849999999999999e-07 0
+ 4.6875000000000001e-07 0
+ 4.6899999999999998e-07 0
+ 4.6925e-07 0
+ 4.6950000000000002e-07 0
+ 4.6974999999999998e-07 0
+ 4.7e-07 0
+ 4.7025000000000002e-07 0
+ 4.7049999999999998e-07 0
+ 4.7075e-07 0
+ 4.7100000000000002e-07 0
+ 4.7124999999999999e-07 0
+ 4.7150000000000001e-07 0
+ 4.7175000000000003e-07 0
+ 4.7199999999999999e-07 0
+ 4.7225000000000001e-07 0
+ 4.7249999999999998e-07 0
+ 4.7274999999999999e-07 0
+ 4.7300000000000001e-07 0
+ 4.7324999999999998e-07 0
+ 4.735e-07 0
+ 4.7375000000000002e-07 0
+ 4.7399999999999998e-07 0
+ 4.7425e-07 0
+ 4.7450000000000002e-07 0
+ 4.7474999999999999e-07 0
+ 4.75e-07 0
+ 4.7525000000000002e-07 0
+ 4.7549999999999999e-07 0
+ 4.7575000000000001e-07 0
+ 4.7599999999999997e-07 0
+ 4.7624999999999999e-07 0
+ 4.7650000000000001e-07 0
+ 4.7674999999999998e-07 0
+ 4.7700000000000005e-07 0
+ 4.7724999999999996e-07 0
+ 4.7749999999999998e-07 0
+ 4.7775e-07 0
+ 4.7800000000000002e-07 0
+ 4.7825000000000004e-07 0
+ 4.7849999999999995e-07 0
+ 4.7874999999999997e-07 0
+ 4.7899999999999999e-07 0
+ 4.7925000000000001e-07 0
+ 4.7950000000000003e-07 0
+ 4.7975000000000004e-07 0
+ 4.7999999999999996e-07 0
+ 4.8024999999999998e-07 0
+ 4.8049999999999999e-07 0
+ 4.8075000000000001e-07 0
+ 4.8100000000000003e-07 0
+ 4.8125000000000005e-07 0
+ 4.8149999999999996e-07 0
+ 4.8174999999999998e-07 0
+ 4.82e-07 0
+ 4.8225000000000002e-07 0
+ 4.8250000000000004e-07 0
+ 4.8274999999999995e-07 0
+ 4.8299999999999997e-07 0
+ 4.8324999999999999e-07 0
+ 4.8350000000000001e-07 0
+ 4.8375000000000003e-07 0
+ 4.8400000000000005e-07 0
+ 4.8424999999999996e-07 0
+ 4.8449999999999998e-07 0
+ 4.8475e-07 0
+ 4.8500000000000002e-07 0
+ 4.8525000000000003e-07 0
+ 4.8550000000000005e-07 0
+ 4.8574999999999997e-07 0
+ 4.8599999999999998e-07 0
+ 4.8625e-07 0
+ 4.8650000000000002e-07 0
+ 4.8675000000000004e-07 0
+ 4.8699999999999995e-07 0
+ 4.8724999999999997e-07 0
+ 4.8749999999999999e-07 0
+ 4.8775000000000001e-07 0
+ 4.8800000000000003e-07 0
+ 4.8825000000000005e-07 0
+ 4.8849999999999996e-07 0
+ 4.8874999999999998e-07 0
+ 4.89e-07 0
+ 4.8925000000000002e-07 0
+ 4.8950000000000004e-07 0
+ 4.8974999999999995e-07 0
+ 4.8999999999999997e-07 0
+ 4.9024999999999999e-07 0
+ 4.905e-07 0
+ 4.9075000000000002e-07 0
+ 4.9100000000000004e-07 0
+ 4.9124999999999996e-07 0
+ 4.9149999999999997e-07 0
+ 4.9174999999999999e-07 0
+ 4.9200000000000001e-07 0
+ 4.9225000000000003e-07 0
+ 4.9250000000000005e-07 0
+ 4.9274999999999996e-07 0
+ 4.9299999999999998e-07 0
+ 4.9325e-07 0
+ 4.9350000000000002e-07 0
+ 4.9375000000000004e-07 0
+ 4.9399999999999995e-07 0
+ 4.9424999999999997e-07 0
+ 4.9449999999999999e-07 0
+ 4.9475000000000001e-07 0
+ 4.9500000000000003e-07 0
+ 4.9525000000000004e-07 0
+ 4.9549999999999996e-07 0
+ 4.9574999999999998e-07 0
+ 4.9599999999999999e-07 0
+ 4.9625000000000001e-07 0
+ 4.9650000000000003e-07 0
+ 4.9675000000000005e-07 0
+ 4.9699999999999996e-07 0
+ 4.9724999999999998e-07 0
+ 4.975e-07 0
+ 4.9775000000000002e-07 0
+ 4.9800000000000004e-07 0
+ 4.9824999999999995e-07 0
+ 4.9849999999999997e-07 0
+ 4.9874999999999999e-07 0
+ 4.9900000000000001e-07 0
+ 4.9925000000000003e-07 0
+ 4.9950000000000005e-07 0
+ 4.9974999999999996e-07 0
+ 4.9999999999999998e-07 0
+ 5.0025e-07 0
+ 5.0050000000000001e-07 0
+ 5.0075000000000003e-07 0
+ 5.0100000000000005e-07 0
+ 5.0124999999999997e-07 0
+ 5.0149999999999998e-07 0
+ 5.0175e-07 0
+ 5.0200000000000002e-07 0
+ 5.0225000000000004e-07 0
+ 5.0249999999999995e-07 0
+ 5.0274999999999997e-07 0
+ 5.0299999999999999e-07 0
+ 5.0325000000000001e-07 0
+ 5.0350000000000003e-07 0
+ 5.0375000000000005e-07 0
+ 5.0399999999999996e-07 0
+ 5.0424999999999998e-07 0
+ 5.045e-07 0
+ 5.0475000000000002e-07 0
+ 5.0500000000000004e-07 0
+ 5.0524999999999995e-07 0
+ 5.0549999999999997e-07 0
+ 5.0574999999999999e-07 0
+ 5.06e-07 0
+ 5.0625000000000002e-07 0
+ 5.0650000000000004e-07 0
+ 5.0674999999999996e-07 0
+ 5.0699999999999997e-07 0
+ 5.0724999999999999e-07 0
+ 5.0750000000000001e-07 0
+ 5.0775000000000003e-07 0
+ 5.0800000000000005e-07 0
+ 5.0824999999999996e-07 0
+ 5.0849999999999998e-07 0
+ 5.0875e-07 0
+ 5.0900000000000002e-07 0
+ 5.0925000000000004e-07 0
+ 5.0949999999999995e-07 0
+ 5.0974999999999997e-07 0
+ 5.0999999999999999e-07 0
+ 5.1025000000000001e-07 0
+ 5.1050000000000003e-07 0
+ 5.1075000000000004e-07 0
+ 5.1093750000000003e-07 0
+ 5.1099999999999996e-07 0
+ 5.1124999999999998e-07 0
+ 5.1149999999999999e-07 0
+ 5.1175000000000001e-07 0
+ 5.1200000000000003e-07 0
+ 5.1225000000000005e-07 0
+ 5.1249999999999996e-07 0
+ 5.1274999999999998e-07 0
+ 5.13e-07 0
+ 5.1325000000000002e-07 0
+ 5.1350000000000004e-07 0
+ 5.1374999999999995e-07 0
+ 5.1399999999999997e-07 0
+ 5.140625e-07 0
+ 5.1424999999999999e-07 0
+ 5.1450000000000001e-07 0
+ 5.1475000000000003e-07 0
+ 5.1500000000000005e-07 0
+ 5.1524999999999996e-07 0
+ 5.1549999999999998e-07 0
+ 5.1562500000000004e-07 0
+ 5.1575e-07 0
+ 5.1600000000000001e-07 0
+ 5.1625000000000003e-07 0
+ 5.1650000000000005e-07 0
+ 5.1674999999999997e-07 0
+ 5.1699999999999998e-07 0
+ 5.1718749999999997e-07 0
+ 5.1725e-07 0
+ 5.1750000000000002e-07 0
+ 5.1775000000000004e-07 0
+ 5.1799999999999995e-07 0
+ 5.1824999999999997e-07 0
+ 5.1849999999999999e-07 0
+ 5.1875000000000001e-07 0
+ 5.1900000000000003e-07 0
+ 5.1925000000000005e-07 0
+ 5.1949999999999996e-07 0
+ 5.1974999999999998e-07 0
+ 5.2e-07 0
+ 5.2025000000000002e-07 0
+ 5.2031250000000005e-07 0
+ 5.2050000000000004e-07 0
+ 5.2074999999999995e-07 0
+ 5.2099999999999997e-07 0
+ 5.2124999999999999e-07 0
+ 5.215e-07 0
+ 5.2175000000000002e-07 0
+ 5.2187499999999998e-07 0
+ 5.2200000000000004e-07 0
+ 5.2224999999999995e-07 0
+ 5.2249999999999997e-07 0
+ 5.2274999999999999e-07 0
+ 5.2300000000000001e-07 0
+ 5.2325000000000003e-07 0
+ 5.2343750000000002e-07 0
+ 5.2350000000000005e-07 0
+ 5.2374999999999996e-07 0
+ 5.2399999999999998e-07 0
+ 5.2425e-07 0
+ 5.2450000000000002e-07 0
+ 5.2475000000000004e-07 0
+ 5.2499999999999995e-07 0
+ 5.2524999999999997e-07 0
+ 5.2549999999999999e-07 0
+ 5.2575000000000001e-07 0
+ 5.2600000000000002e-07 0
+ 5.2625000000000004e-07 0
+ 5.2649999999999996e-07 0
+ 5.2656249999999999e-07 0
+ 5.2674999999999998e-07 0
+ 5.2699999999999999e-07 0
+ 5.2725000000000001e-07 0
+ 5.2750000000000003e-07 0
+ 5.2775000000000005e-07 0
+ 5.2799999999999996e-07 0
+ 5.2812500000000003e-07 0
+ 5.2824999999999998e-07 0
+ 5.285e-07 0
+ 5.2875000000000002e-07 0
+ 5.2900000000000004e-07 0
+ 5.2924999999999995e-07 0
+ 5.2949999999999997e-07 0
+ 5.2968749999999996e-07 0
+ 5.2974999999999999e-07 0
+ 5.3000000000000001e-07 0
+ 5.3025000000000003e-07 0
+ 5.3050000000000005e-07 0
+ 5.3074999999999996e-07 0
+ 5.3099999999999998e-07 0
+ 5.3125e-07 0
+ 5.3150000000000001e-07 0
+ 5.3175000000000003e-07 0
+ 5.3200000000000005e-07 0
+ 5.3224999999999997e-07 0
+ 5.3249999999999998e-07 0
+ 5.3275e-07 0
+ 5.3281250000000003e-07 0
+ 5.3300000000000002e-07 0
+ 5.3325000000000004e-07 0
+ 5.3349999999999995e-07 0
+ 5.3374999999999997e-07 0
+ 5.3399999999999999e-07 0
+ 5.3425000000000001e-07 0
+ 5.3437499999999997e-07 0
+ 5.3450000000000003e-07 0
+ 5.3475000000000005e-07 0
+ 5.3499999999999996e-07 0
+ 5.3524999999999998e-07 0
+ 5.355e-07 0
+ 5.3575000000000002e-07 0
+ 5.359375e-07 0
+ 5.3600000000000004e-07 0
+ 5.3624999999999995e-07 0
+ 5.3649999999999997e-07 0
+ 5.3674999999999999e-07 0
+ 5.37e-07 0
+ 5.3725000000000002e-07 0
+ 5.3750000000000004e-07 0
+ 5.3774999999999995e-07 0
+ 5.3799999999999997e-07 0
+ 5.3824999999999999e-07 0
+ 5.3850000000000001e-07 0
+ 5.3875000000000003e-07 0
+ 5.3900000000000005e-07 0
+ 5.3906249999999997e-07 0
+ 5.3924999999999996e-07 0
+ 5.3949999999999998e-07 0
+ 5.3975e-07 0
+ 5.4000000000000002e-07 0
+ 5.4025000000000004e-07 0
+ 5.4049999999999995e-07 0
+ 5.4062500000000001e-07 0
+ 5.4074999999999997e-07 0
+ 5.4099999999999999e-07 0
+ 5.4125000000000001e-07 0
+ 5.4150000000000002e-07 0
+ 5.4175000000000004e-07 0
+ 5.4199999999999996e-07 0
+ 5.4218750000000005e-07 0
+ 5.4224999999999998e-07 0
+ 5.4249999999999999e-07 0
+ 5.4275000000000001e-07 0
+ 5.4300000000000003e-07 0
+ 5.4325000000000005e-07 0
+ 5.4349999999999996e-07 0
+ 5.4374999999999998e-07 0
+ 5.44e-07 0
+ 5.4425000000000002e-07 0
+ 5.4450000000000004e-07 0
+ 5.4474999999999995e-07 0
+ 5.4499999999999997e-07 0
+ 5.4524999999999999e-07 0
+ 5.4531250000000002e-07 0
+ 5.4550000000000001e-07 0
+ 5.4575000000000003e-07 0
+ 5.4600000000000005e-07 0
+ 5.4624999999999996e-07 0
+ 5.4649999999999998e-07 0
+ 5.4675e-07 0
+ 5.4687499999999995e-07 0
+ 5.4700000000000001e-07 0
+ 5.4725000000000003e-07 0
+ 5.4750000000000005e-07 0
+ 5.4774999999999996e-07 0
+ 5.4799999999999998e-07 0
+ 5.4825e-07 0
+ 5.4843749999999999e-07 0
+ 5.4850000000000002e-07 0
+ 5.4875000000000004e-07 0
+ 5.4899999999999995e-07 0
+ 5.4924999999999997e-07 0
+ 5.4949999999999999e-07 0
+ 5.4975000000000001e-07 0
+ 5.5000000000000003e-07 0
+ 5.5025000000000005e-07 0
+ 5.5049999999999996e-07 0
+ 5.5074999999999998e-07 0
+ 5.51e-07 0
+ 5.5125000000000002e-07 0
+ 5.5150000000000003e-07 0
+ 5.5156249999999996e-07 0
+ 5.5174999999999995e-07 0
+ 5.5199999999999997e-07 0
+ 5.5224999999999999e-07 0
+ 5.525e-07 0
+ 5.5275000000000002e-07 0
+ 5.5300000000000004e-07 0
+ 5.53125e-07 0
+ 5.5324999999999995e-07 0
+ 5.5349999999999997e-07 0
+ 5.5374999999999999e-07 0
+ 5.5400000000000001e-07 0
+ 5.5425000000000003e-07 0
+ 5.5450000000000005e-07 0
+ 5.5468750000000004e-07 0
+ 5.5474999999999996e-07 0
+ 5.5499999999999998e-07 0
+ 5.5525e-07 0
+ 5.5550000000000002e-07 0
+ 5.5575000000000004e-07 0
+ 5.5599999999999995e-07 0
+ 5.5624999999999997e-07 0
+ 5.5649999999999999e-07 0
+ 5.5675000000000001e-07 0
+ 5.5700000000000002e-07 0
+ 5.5725000000000004e-07 0
+ 5.5749999999999996e-07 0
+ 5.5774999999999998e-07 0
+ 5.5781250000000001e-07 0
+ 5.5799999999999999e-07 0
+ 5.5825000000000001e-07 0
+ 5.5850000000000003e-07 0
+ 5.5875000000000005e-07 0
+ 5.5899999999999996e-07 0
+ 5.5924999999999998e-07 0
+ 5.5937500000000004e-07 0
+ 5.595e-07 0
+ 5.5975000000000002e-07 0
+ 5.6000000000000004e-07 0
+ 5.6024999999999995e-07 0
+ 5.6049999999999997e-07 0
+ 5.6074999999999999e-07 0
+ 5.6093749999999998e-07 0
+ 5.6100000000000001e-07 0
+ 5.6125000000000003e-07 0
+ 5.6150000000000005e-07 0
+ 5.6174999999999996e-07 0
+ 5.6199999999999998e-07 0
+ 5.6225e-07 0
+ 5.6250000000000001e-07 0
+ 5.6275000000000003e-07 0
+ 5.6300000000000005e-07 0
+ 5.6324999999999996e-07 0
+ 5.6349999999999998e-07 0
+ 5.6375e-07 0
+ 5.6400000000000002e-07 0
+ 5.6406250000000005e-07 0
+ 5.6425000000000004e-07 0
+ 5.6449999999999995e-07 0
+ 5.6474999999999997e-07 0
+ 5.6499999999999999e-07 0
+ 5.6525000000000001e-07 0
+ 5.6550000000000003e-07 0
+ 5.6562499999999998e-07 0
+ 5.6575000000000005e-07 0
+ 5.6599999999999996e-07 0
+ 5.6624999999999998e-07 0
+ 5.665e-07 0
+ 5.6675000000000002e-07 0
+ 5.6700000000000003e-07 0
+ 5.6718750000000002e-07 0
+ 5.6724999999999995e-07 0
+ 5.6749999999999997e-07 0
+ 5.6774999999999999e-07 0
+ 5.68e-07 0
+ 5.6825000000000002e-07 0
+ 5.6850000000000004e-07 0
+ 5.6874999999999995e-07 0
+ 5.6899999999999997e-07 0
+ 5.6924999999999999e-07 0
+ 5.6950000000000001e-07 0
+ 5.6975000000000003e-07 0
+ 5.7000000000000005e-07 0
+ 5.7024999999999996e-07 0
+ 5.7031249999999999e-07 0
+ 5.70497e-07 0
+ 5.7049999999999998e-07 0
+ 5.7075e-07 0
+ 5.7100000000000002e-07 0
+ 5.7125000000000004e-07 0
+ 5.7149999999999995e-07 0
+ 5.7174999999999997e-07 0
+ 5.7187500000000003e-07 0
+ 5.7199999999999999e-07 0
+ 5.7225000000000001e-07 0
+ 5.7250000000000002e-07 0
+ 5.7275000000000004e-07 0
+ 5.7299999999999996e-07 0
+ 5.7324999999999997e-07 0
+ 5.7343749999999996e-07 0
+ 5.7349999999999999e-07 0
+ 5.7375000000000001e-07 0
+ 5.7400000000000003e-07 0
+ 5.7425000000000005e-07 0
+ 5.7449999999999996e-07 0
+ 5.7474999999999998e-07 0
+ 5.75e-07 0
+ 5.7525000000000002e-07 0
+ 5.7550000000000004e-07 0
+ 5.7574999999999995e-07 0
+ 5.7599999999999997e-07 0
+ 5.7624999999999999e-07 0
+ 5.7650000000000001e-07 0
+ 5.7656250000000004e-07 0
+ 5.7675000000000003e-07 0
+ 5.7700000000000004e-07 0
+ 5.7724999999999996e-07 0
+ 5.7749999999999998e-07 0
+ 5.7775e-07 0
+ 5.7800000000000001e-07 0
+ 5.7812499999999997e-07 0
+ 5.7825000000000003e-07 0
+ 5.7850000000000005e-07 0
+ 5.7874999999999996e-07 0
+ 5.7899999999999998e-07 0
+ 5.7925e-07 0
+ 5.7950000000000002e-07 0
+ 5.7968750000000001e-07 0
+ 5.7975000000000004e-07 0
+ 5.7999999999999995e-07 0
+ 5.8024999999999997e-07 0
+ 5.8049999999999999e-07 0
+ 5.8075000000000001e-07 0
+ 5.8100000000000003e-07 0
+ 5.8125000000000005e-07 0
+ 5.8149999999999996e-07 0
+ 5.8174999999999998e-07 0
+ 5.82e-07 0
+ 5.8225000000000002e-07 0
+ 5.8250000000000003e-07 0
+ 5.8274999999999995e-07 0
+ 5.8281249999999998e-07 0
+ 5.8299999999999997e-07 0
+ 5.8324999999999998e-07 0
+ 5.835e-07 0
+ 5.8375000000000002e-07 0
+ 5.8400000000000004e-07 0
+ 5.8424999999999995e-07 0
+ 5.8437500000000002e-07 0
+ 5.8449999999999997e-07 0
+ 5.8474999999999999e-07 0
+ 5.8500000000000001e-07 0
+ 5.8525000000000003e-07 0
+ 5.8550000000000005e-07 0
+ 5.8574999999999996e-07 0
+ 5.8593749999999995e-07 0
+ 5.8599999999999998e-07 0
+ 5.8625e-07 0
+ 5.8650000000000002e-07 0
+ 5.8675000000000004e-07 0
+ 5.8699999999999995e-07 0
+ 5.8724999999999997e-07 0
+ 5.8749999999999999e-07 0
+ 5.8775000000000001e-07 0
+ 5.8800000000000002e-07 0
+ 5.8825000000000004e-07 0
+ 5.8849999999999996e-07 0
+ 5.8874999999999997e-07 0
+ 5.8899999999999999e-07 0
+ 5.8906250000000002e-07 0
+ 5.8925000000000001e-07 0
+ 5.8950000000000003e-07 0
+ 5.8975000000000005e-07 0
+ 5.8999999999999996e-07 0
+ 5.9024999999999998e-07 0
+ 5.905e-07 0
+ 5.9062499999999996e-07 0
+ 5.9075000000000002e-07 0
+ 5.9100000000000004e-07 0
+ 5.9124999999999995e-07 0
+ 5.9149999999999997e-07 0
+ 5.9174999999999999e-07 0
+ 5.9200000000000001e-07 0
+ 5.9218749999999999e-07 0
+ 5.9225000000000003e-07 0
+ 5.9250000000000004e-07 0
+ 5.9274999999999996e-07 0
+ 5.9299999999999998e-07 0
+ 5.9325e-07 0
+ 5.9350000000000001e-07 0
+ 5.9375000000000003e-07 0
+ 5.9400000000000005e-07 0
+ 5.9424999999999996e-07 0
+ 5.9449999999999998e-07 0
+ 5.9475e-07 0
+ 5.9500000000000002e-07 0
+ 5.9525000000000004e-07 0
+ 5.9531249999999996e-07 0
+ 5.9549999999999995e-07 0
+ 5.9574999999999997e-07 0
+ 5.9599999999999999e-07 0
+ 5.9625000000000001e-07 0
+ 5.9650000000000003e-07 0
+ 5.9675000000000005e-07 0
+ 5.96875e-07 0
+ 5.9699999999999996e-07 0
+ 5.9724999999999998e-07 0
+ 5.975e-07 0
+ 5.9775000000000002e-07 0
+ 5.9800000000000003e-07 0
+ 5.9824999999999995e-07 0
+ 5.9843750000000004e-07 0
+ 5.9849999999999997e-07 0
+ 5.9874999999999998e-07 0
+ 5.99e-07 0
+ 5.9925000000000002e-07 0
+ 5.9950000000000004e-07 0
+ 5.9974999999999995e-07 0
+ 5.9999999999999997e-07 0
+ 6.0024999999999999e-07 0
+ 6.0050000000000001e-07 0
+ 6.0075000000000003e-07 0
+ 6.0100000000000005e-07 0
+ 6.0124999999999996e-07 0
+ 6.0149999999999998e-07 0
+ 6.0156250000000001e-07 0
+ 6.0175e-07 0
+ 6.0200000000000002e-07 0
+ 6.0225000000000004e-07 0
+ 6.0249999999999995e-07 0
+ 6.0274999999999997e-07 0
+ 6.0299999999999999e-07 0
+ 6.0312500000000005e-07 0
+ 6.0325000000000001e-07 0
+ 6.0350000000000002e-07 0
+ 6.0375000000000004e-07 0
+ 6.0399999999999996e-07 0
+ 6.0424999999999997e-07 0
+ 6.0449999999999999e-07 0
+ 6.0468749999999998e-07 0
+ 6.0475000000000001e-07 0
+ 6.0500000000000003e-07 0
+ 6.0525000000000005e-07 0
+ 6.0549999999999996e-07 0
+ 6.0574999999999998e-07 0
+ 6.06e-07 0
+ 6.0625000000000002e-07 0
+ 6.0650000000000004e-07 0
+ 6.0674999999999995e-07 0
+ 6.0699999999999997e-07 0
+ 6.0724999999999999e-07 0
+ 6.0750000000000001e-07 0
+ 6.0775000000000003e-07 0
+ 6.0781249999999995e-07 0
+ 6.0800000000000004e-07 0
+ 6.0824999999999996e-07 0
+ 6.0849999999999998e-07 0
+ 6.0874999999999999e-07 0
+ 6.0900000000000001e-07 0
+ 6.0925000000000003e-07 0
+ 6.0937499999999999e-07 0
+ 6.0950000000000005e-07 0
+ 6.0974999999999996e-07 0
+ 6.0999999999999998e-07 0
+ 6.1025e-07 0
+ 6.1050000000000002e-07 0
+ 6.1075000000000004e-07 0
+ 6.1093750000000003e-07 0
+ 6.1099999999999995e-07 0
+ 6.1124999999999997e-07 0
+ 6.1149999999999999e-07 0
+ 6.1175000000000001e-07 0
+ 6.1200000000000003e-07 0
+ 6.1225000000000005e-07 0
+ 6.1249999999999996e-07 0
+ 6.1274999999999998e-07 0
+ 6.13e-07 0
+ 6.1325000000000002e-07 0
+ 6.1350000000000003e-07 0
+ 6.1374999999999995e-07 0
+ 6.1399999999999997e-07 0
+ 6.140625e-07 0
+ 6.1424999999999998e-07 0
+ 6.145e-07 0
+ 6.1475000000000002e-07 0
+ 6.1500000000000004e-07 0
+ 6.1524999999999995e-07 0
+ 6.1549999999999997e-07 0
+ 6.1562500000000004e-07 0
+ 6.1574999999999999e-07 0
+ 6.1600000000000001e-07 0
+ 6.1625000000000003e-07 0
+ 6.1650000000000005e-07 0
+ 6.1674999999999996e-07 0
+ 6.1699999999999998e-07 0
+ 6.1718749999999997e-07 0
+ 6.1725e-07 0
+ 6.1750000000000002e-07 0
+ 6.1775000000000004e-07 0
+ 6.1799999999999995e-07 0
+ 6.1824999999999997e-07 0
+ 6.1849999999999999e-07 0
+ 6.1875000000000001e-07 0
+ 6.1900000000000002e-07 0
+ 6.1925000000000004e-07 0
+ 6.1949999999999996e-07 0
+ 6.1974999999999997e-07 0
+ 6.1999999999999999e-07 0
+ 6.2025000000000001e-07 0
+ 6.2031250000000004e-07 0
+ 6.2050000000000003e-07 0
+ 6.2075000000000005e-07 0
+ 6.2099999999999996e-07 0
+ 6.2124999999999998e-07 0
+ 6.215e-07 0
+ 6.2175000000000002e-07 0
+ 6.2187499999999998e-07 0
+ 6.2200000000000004e-07 0
+ 6.2224999999999995e-07 0
+ 6.2249999999999997e-07 0
+ 6.2274999999999999e-07 0
+ 6.2300000000000001e-07 0
+ 6.2325000000000003e-07 0
+ 6.2343750000000001e-07 0
+ 6.2350000000000004e-07 0
+ 6.2374999999999996e-07 0
+ 6.2399999999999998e-07 0
+ 6.2424999999999999e-07 0
+ 6.2450000000000001e-07 0
+ 6.2475000000000003e-07 0
+ 6.2500000000000005e-07 0
+ 6.2524999999999996e-07 0
+ 6.2549999999999998e-07 0
+ 6.2575e-07 0
+ 6.2600000000000002e-07 0
+ 6.2625000000000004e-07 0
+ 6.2649999999999995e-07 0
+ 6.2656249999999998e-07 0
+ 6.2674999999999997e-07 0
+ 6.2699999999999999e-07 0
+ 6.2725000000000001e-07 0
+ 6.2750000000000003e-07 0
+ 6.2775000000000005e-07 0
+ 6.2799999999999996e-07 0
+ 6.2812500000000002e-07 0
+ 6.2824999999999998e-07 0
+ 6.285e-07 0
+ 6.2875000000000002e-07 0
+ 6.2900000000000003e-07 0
+ 6.2925000000000005e-07 0
+ 6.2949999999999997e-07 0
+ 6.2968749999999995e-07 0
+ 6.2974999999999998e-07 0
+ 6.3e-07 0
+ 6.3025000000000002e-07 0
+ 6.3050000000000004e-07 0
+ 6.3074999999999995e-07 0
+ 6.3099999999999997e-07 0
+ 6.3124999999999999e-07 0
+ 6.3150000000000001e-07 0
+ 6.3175000000000003e-07 0
+ 6.3200000000000005e-07 0
+ 6.3224999999999996e-07 0
+ 6.3249999999999998e-07 0
+ 6.3275e-07 0
+ 6.3281250000000003e-07 0
+ 6.3299700000000004e-07 0
+ 6.3300000000000002e-07 0
+ 6.3325000000000004e-07 0
+ 6.3349999999999995e-07 0
+ 6.3374999999999997e-07 0
+ 6.3399999999999999e-07 0
+ 6.3425e-07 0
+ 6.3437499999999996e-07 0
+ 6.3450000000000002e-07 0
+ 6.3475000000000004e-07 0
+ 6.3499999999999996e-07 0
+ 6.3524999999999997e-07 0
+ 6.3549999999999999e-07 0
+ 6.3575000000000001e-07 0
+ 6.359375e-07 0
+ 6.3600000000000003e-07 0
+ 6.3625000000000005e-07 0
+ 6.3649999999999996e-07 0
+ 6.3674999999999998e-07 0
+ 6.37e-07 0
+ 6.3725000000000002e-07 0
+ 6.3750000000000004e-07 0
+ 6.3774999999999995e-07 0
+ 6.3799999999999997e-07 0
+ 6.3824999999999999e-07 0
+ 6.3850000000000001e-07 0
+ 6.3875000000000003e-07 0
+ 6.3900000000000004e-07 0
+ 6.3906249999999997e-07 0
+ 6.3924999999999996e-07 0
+ 6.3949999999999998e-07 0
+ 6.3974999999999999e-07 0
+ 6.4000000000000001e-07 0
+ 6.4025000000000003e-07 0
+ 6.4050000000000005e-07 0
+ 6.4062500000000001e-07 0
+ 6.4074999999999996e-07 0
+ 6.4099999999999998e-07 0
+ 6.4125e-07 0
+ 6.4150000000000002e-07 0
+ 6.4175000000000004e-07 0
+ 6.4199999999999995e-07 0
+ 6.4218750000000005e-07 0
+ 6.4224999999999997e-07 0
+ 6.4249999999999999e-07 0
+ 6.4275000000000001e-07 0
+ 6.4300000000000003e-07 0
+ 6.4325000000000005e-07 0
+ 6.4349999999999996e-07 0
+ 6.4374999999999998e-07 0
+ 6.44e-07 0
+ 6.4425000000000002e-07 0
+ 6.4450000000000003e-07 0
+ 6.4475000000000005e-07 0
+ 6.4499999999999997e-07 0
+ 6.4524999999999998e-07 0
+ 6.4531250000000002e-07 0
+ 6.455e-07 0
+ 6.4575000000000002e-07 0
+ 6.4600000000000004e-07 0
+ 6.4624999999999995e-07 0
+ 6.4649999999999997e-07 0
+ 6.4674999999999999e-07 0
+ 6.4687499999999995e-07 0
+ 6.4700000000000001e-07 0
+ 6.4725000000000003e-07 0
+ 6.4750000000000005e-07 0
+ 6.4774999999999996e-07 0
+ 6.4799999999999998e-07 0
+ 6.4825e-07 0
+ 6.4843749999999999e-07 0
+ 6.4850000000000002e-07 0
+ 6.4875000000000004e-07 0
+ 6.4899999999999995e-07 0
+ 6.4924999999999997e-07 0
+ 6.4949999999999999e-07 0
+ 6.4975e-07 0
+ 6.5000000000000002e-07 0
+ 6.5025000000000004e-07 0
+ 6.5049999999999996e-07 0
+ 6.5074999999999997e-07 0
+ 6.5099999999999999e-07 0
+ 6.5125000000000001e-07 0
+ 6.5150000000000003e-07 0
+ 6.5156249999999996e-07 0
+ 6.5175000000000005e-07 0
+ 6.5199999999999996e-07 0
+ 6.5224999999999998e-07 0
+ 6.525e-07 0
+ 6.5275000000000002e-07 0
+ 6.5300000000000004e-07 0
+ 6.5312499999999999e-07 0
+ 6.5324999999999995e-07 0
+ 6.5349999999999997e-07 0
+ 6.5374999999999999e-07 0
+ 6.5400000000000001e-07 0
+ 6.5425000000000003e-07 0
+ 6.5450000000000004e-07 0
+ 6.5468750000000003e-07 0
+ 6.5474999999999996e-07 0
+ 6.5499999999999998e-07 0
+ 6.5524999999999999e-07 0
+ 6.5550000000000001e-07 0
+ 6.5575000000000003e-07 0
+ 6.5600000000000005e-07 0
+ 6.5624999999999996e-07 0
+ 6.5649999999999998e-07 0
+ 6.5675e-07 0
+ 6.5700000000000002e-07 0
+ 6.5725000000000004e-07 0
+ 6.5749999999999995e-07 0
+ 6.5774999999999997e-07 0
+ 6.578125e-07 0
+ 6.5799999999999999e-07 0
+ 6.5825000000000001e-07 0
+ 6.5850000000000003e-07 0
+ 6.5875000000000005e-07 0
+ 6.5899999999999996e-07 0
+ 6.5924999999999998e-07 0
+ 6.5937500000000004e-07 0
+ 6.595e-07 0
+ 6.5975000000000001e-07 0
+ 6.6000000000000003e-07 0
+ 6.6025000000000005e-07 0
+ 6.6049999999999997e-07 0
+ 6.6074999999999998e-07 0
+ 6.6093749999999997e-07 0
+ 6.61e-07 0
+ 6.6125000000000002e-07 0
+ 6.6150000000000004e-07 0
+ 6.6174999999999995e-07 0
+ 6.6199999999999997e-07 0
+ 6.6224999999999999e-07 0
+ 6.6250000000000001e-07 0
+ 6.6275000000000003e-07 0
+ 6.6300000000000005e-07 0
+ 6.6324999999999996e-07 0
+ 6.6349999999999998e-07 0
+ 6.6375e-07 0
+ 6.6400000000000002e-07 0
+ 6.6406250000000005e-07 0
+ 6.6425000000000004e-07 0
+ 6.6449999999999995e-07 0
+ 6.6474999999999997e-07 0
+ 6.6499999999999999e-07 0
+ 6.6525e-07 0
+ 6.6550000000000002e-07 0
+ 6.6562499999999998e-07 0
+ 6.6575000000000004e-07 0
+ 6.6599999999999996e-07 0
+ 6.6624999999999997e-07 0
+ 6.6649999999999999e-07 0
+ 6.6675000000000001e-07 0
+ 6.6700000000000003e-07 0
+ 6.6718750000000002e-07 0
+ 6.6725000000000005e-07 0
+ 6.6749999999999996e-07 0
+ 6.6774999999999998e-07 0
+ 6.68e-07 0
+ 6.6825000000000002e-07 0
+ 6.6850000000000004e-07 0
+ 6.6874999999999995e-07 0
+ 6.6899999999999997e-07 0
+ 6.6924999999999999e-07 0
+ 6.6950000000000001e-07 0
+ 6.6975000000000003e-07 0
+ 6.7000000000000004e-07 0
+ 6.7024999999999996e-07 0
+ 6.7031249999999999e-07 0
+ 6.7049999999999998e-07 0
+ 6.7074999999999999e-07 0
+ 6.7100000000000001e-07 0
+ 6.7125000000000003e-07 0
+ 6.7150000000000005e-07 0
+ 6.7174999999999996e-07 0
+ 6.7187500000000003e-07 0
+ 6.7199999999999998e-07 0
+ 6.7225e-07 0
+ 6.7250000000000002e-07 0
+ 6.7275000000000004e-07 0
+ 6.7299999999999995e-07 0
+ 6.7324999999999997e-07 0
+ 6.7343749999999996e-07 0
+ 6.7349999999999999e-07 0
+ 6.7375000000000001e-07 0
+ 6.7400000000000003e-07 0
+ 6.7425000000000005e-07 0
+ 6.7449999999999996e-07 0
+ 6.7474999999999998e-07 0
+ 6.75e-07 0
+ 6.7525000000000001e-07 0
+ 6.7550000000000003e-07 0
+ 6.7575000000000005e-07 0
+ 6.7599999999999997e-07 0
+ 6.7624999999999998e-07 0
+ 6.765e-07 0
+ 6.7656250000000003e-07 0
+ 6.7675000000000002e-07 0
+ 6.7700000000000004e-07 0
+ 6.7724999999999995e-07 0
+ 6.7749999999999997e-07 0
+ 6.7774999999999999e-07 0
+ 6.7800000000000001e-07 0
+ 6.7812499999999997e-07 0
+ 6.7825000000000003e-07 0
+ 6.7850000000000005e-07 0
+ 6.7874999999999996e-07 0
+ 6.7899999999999998e-07 0
+ 6.7925e-07 0
+ 6.7950000000000002e-07 0
+ 6.796875e-07 0
+ 6.7975000000000004e-07 0
+ 6.7999999999999995e-07 0
+ 6.8024999999999997e-07 0
+ 6.8049999999999999e-07 0
+ 6.8075e-07 0
+ 6.8100000000000002e-07 0
+ 6.8125000000000004e-07 0
+ 6.8149999999999995e-07 0
+ 6.8174999999999997e-07 0
+ 6.8199999999999999e-07 0
+ 6.8225000000000001e-07 0
+ 6.8250000000000003e-07 0
+ 6.8275000000000005e-07 0
+ 6.8281249999999997e-07 0
+ 6.8299999999999996e-07 0
+ 6.8324999999999998e-07 0
+ 6.835e-07 0
+ 6.8375000000000002e-07 0
+ 6.8400000000000004e-07 0
+ 6.8424999999999995e-07 0
+ 6.8437500000000001e-07 0
+ 6.8449999999999997e-07 0
+ 6.8474999999999999e-07 0
+ 6.8500000000000001e-07 0
+ 6.8525000000000002e-07 0
+ 6.8550000000000004e-07 0
+ 6.8574999999999996e-07 0
+ 6.8593750000000005e-07 0
+ 6.8599999999999998e-07 0
+ 6.8624999999999999e-07 0
+ 6.8650000000000001e-07 0
+ 6.8675000000000003e-07 0
+ 6.8700000000000005e-07 0
+ 6.8724999999999996e-07 0
+ 6.8749999999999998e-07 0
+ 6.8775e-07 0
+ 6.8800000000000002e-07 0
+ 6.8825000000000004e-07 0
+ 6.8849999999999995e-07 0
+ 6.8874999999999997e-07 0
+ 6.8899999999999999e-07 0
+ 6.8906250000000002e-07 0
+ 6.8925000000000001e-07 0
+ 6.8950000000000003e-07 0
+ 6.8975000000000005e-07 0
+ 6.8999999999999996e-07 0
+ 6.9024999999999998e-07 0
+ 6.905e-07 0
+ 6.9062499999999995e-07 0
+ 6.9075000000000001e-07 0
+ 6.9100000000000003e-07 0
+ 6.9125000000000005e-07 0
+ 6.9149999999999997e-07 0
+ 6.9174999999999998e-07 0
+ 6.92e-07 0
+ 6.9218749999999999e-07 0
+ 6.9225000000000002e-07 0
+ 6.9250000000000004e-07 0
+ 6.9274999999999995e-07 0
+ 6.9299999999999997e-07 0
+ 6.9324999999999999e-07 0
+ 6.9350000000000001e-07 0
+ 6.9375000000000003e-07 0
+ 6.9400000000000005e-07 0
+ 6.9424999999999996e-07 0
+ 6.9449999999999998e-07 0
+ 6.9475e-07 0
+ 6.9500000000000002e-07 0
+ 6.9525000000000003e-07 0
+ 6.9531249999999996e-07 0
+ 6.9549999999999995e-07 0
+ 6.9574999999999997e-07 0
+ 6.9599999999999999e-07 0
+ 6.9625e-07 0
+ 6.9650000000000002e-07 0
+ 6.9675000000000004e-07 0
+ 6.96875e-07 0
+ 6.9699999999999995e-07 0
+ 6.9724999999999997e-07 0
+ 6.9749999999999999e-07 0
+ 6.9775000000000001e-07 0
+ 6.9800000000000003e-07 0
+ 6.9825000000000005e-07 0
+ 6.9843750000000004e-07 0
+ 6.9849999999999996e-07 0
+ 6.9874999999999998e-07 0
+ 6.99e-07 0
+ 6.9925000000000002e-07 0
+ 6.9950000000000004e-07 0
+ 6.9974999999999995e-07 0
+ 6.9999999999999997e-07 0
+ 7.0024999999999999e-07 0
+ 7.0050000000000001e-07 0
+ 7.0075000000000002e-07 0
+ 7.0100000000000004e-07 0
+ 7.0124999999999996e-07 0
+ 7.0149999999999998e-07 0
+ 7.0156250000000001e-07 0
+ 7.0174999999999999e-07 0
+ 7.0200000000000001e-07 0
+ 7.0225000000000003e-07 0
+ 7.0250000000000005e-07 0
+ 7.0274999999999996e-07 0
+ 7.0299999999999998e-07 0
+ 7.0312500000000004e-07 0
+ 7.0325e-07 0
+ 7.0350000000000002e-07 0
+ 7.0375000000000004e-07 0
+ 7.0399999999999995e-07 0
+ 7.0424999999999997e-07 0
+ 7.0449999999999999e-07 0
+ 7.0468749999999998e-07 0
+ 7.0475000000000001e-07 0
+ 7.0500000000000003e-07 0
+ 7.0525000000000005e-07 0
+ 7.0549999999999996e-07 0
+ 7.0574999999999998e-07 0
+ 7.06e-07 0
+ 7.0625000000000001e-07 0
+ 7.0650000000000003e-07 0
+ 7.0675000000000005e-07 0
+ 7.0699999999999996e-07 0
+ 7.0724999999999998e-07 0
+ 7.075e-07 0
+ 7.0775000000000002e-07 0
+ 7.0781250000000005e-07 0
+ 7.0800000000000004e-07 0
+ 7.0824999999999995e-07 0
+ 7.0849999999999997e-07 0
+ 7.0874999999999999e-07 0
+ 7.0900000000000001e-07 0
+ 7.0925000000000003e-07 0
+ 7.0937499999999998e-07 0
+ 7.0950000000000005e-07 0
+ 7.0974999999999996e-07 0
+ 7.0999999999999998e-07 0
+ 7.1025e-07 0
+ 7.1050000000000002e-07 0
+ 7.1075000000000003e-07 0
+ 7.1099999999999995e-07 0
+ 7.1124999999999997e-07 0
+ 7.1149999999999999e-07 0
+ 7.1175e-07 0
+ 7.1200000000000002e-07 0
+ 7.1225000000000004e-07 0
+ 7.1249999999999995e-07 0
+ 7.1274999999999997e-07 0
+ 7.1299999999999999e-07 0
+ 7.1325000000000001e-07 0
+ 7.1350000000000003e-07 0
+ 7.1375000000000005e-07 0
+ 7.1399999999999996e-07 0
+ 7.1424999999999998e-07 0
+ 7.145e-07 0
+ 7.1475000000000002e-07 0
+ 7.1500000000000004e-07 0
+ 7.1524999999999995e-07 0
+ 7.1549999999999997e-07 0
+ 7.1574999999999999e-07 0
+ 7.1600000000000001e-07 0
+ 7.1625000000000002e-07 0
+ 7.1650000000000004e-07 0
+ 7.1674999999999996e-07 0
+ 7.1699999999999997e-07 0
+ 7.1724999999999999e-07 0
+ 7.1750000000000001e-07 0
+ 7.1775000000000003e-07 0
+ 7.1800000000000005e-07 0
+ 7.1824999999999996e-07 0
+ 7.1849999999999998e-07 0
+ 7.1875e-07 0
+ 7.1900000000000002e-07 0
+ 7.1925000000000004e-07 0
+ 7.1949999999999995e-07 0
+ 7.1974999999999997e-07 0
+ 7.1999999999999999e-07 0
+ 7.2025000000000001e-07 0
+ 7.2050000000000003e-07 0
+ 7.2075000000000004e-07 0
+ 7.2099999999999996e-07 0
+ 7.2124999999999998e-07 0
+ 7.215e-07 0
+ 7.2175000000000001e-07 0
+ 7.2200000000000003e-07 0
+ 7.2225000000000005e-07 0
+ 7.2249999999999996e-07 0
+ 7.2274999999999998e-07 0
+ 7.23e-07 0
+ 7.2325000000000002e-07 0
+ 7.2350000000000004e-07 0
+ 7.2374999999999995e-07 0
+ 7.2399999999999997e-07 0
+ 7.2424999999999999e-07 0
+ 7.2450000000000001e-07 0
+ 7.2475000000000003e-07 0
+ 7.2500000000000005e-07 0
+ 7.2524999999999996e-07 0
+ 7.2549999999999998e-07 0
+ 7.2575e-07 0
+ 7.2600000000000002e-07 0
+ 7.2625000000000003e-07 0
+ 7.2649999999999995e-07 0
+ 7.2674999999999997e-07 0
+ 7.2699999999999999e-07 0
+ 7.2725e-07 0
+ 7.2750000000000002e-07 0
+ 7.2775000000000004e-07 0
+ 7.2799999999999995e-07 0
+ 7.2824999999999997e-07 0
+ 7.2849999999999999e-07 0
+ 7.2875000000000001e-07 0
+ 7.2900000000000003e-07 0
+ 7.2925000000000005e-07 0
+ 7.2949999999999996e-07 0
+ 7.2974999999999998e-07 0
+ 7.3e-07 0
+ 7.3025000000000002e-07 0
+ 7.3050000000000004e-07 0
+ 7.3074999999999995e-07 0
+ 7.3099999999999997e-07 0
+ 7.3124999999999999e-07 0
+ 7.3150000000000001e-07 0
+ 7.3175000000000002e-07 0
+ 7.3200000000000004e-07 0
+ 7.3224999999999996e-07 0
+ 7.3249999999999997e-07 0
+ 7.3274999999999999e-07 0
+ 7.3300000000000001e-07 0
+ 7.3325000000000003e-07 0
+ 7.3350000000000005e-07 0
+ 7.3374999999999996e-07 0
+ 7.3399999999999998e-07 0
+ 7.3425e-07 0
+ 7.3450000000000002e-07 0
+ 7.3475000000000004e-07 0
+ 7.3499999999999995e-07 0
+ 7.3524999999999997e-07 0
+ 7.3549999999999999e-07 0
+ 7.3575000000000001e-07 0
+ 7.3600000000000003e-07 0
+ 7.3625000000000004e-07 0
+ 7.3649999999999996e-07 0
+ 7.3674999999999998e-07 0
+ 7.37e-07 0
+ 7.3725000000000001e-07 0
+ 7.3750000000000003e-07 0
+ 7.3775000000000005e-07 0
+ 7.3799999999999996e-07 0
+ 7.3824999999999998e-07 0
+ 7.385e-07 0
+ 7.3875000000000002e-07 0
+ 7.3900000000000004e-07 0
+ 7.3924999999999995e-07 0
+ 7.3949999999999997e-07 0
+ 7.3974999999999999e-07 0
+ 7.4000000000000001e-07 0
+ 7.4025000000000003e-07 0
+ 7.4050000000000005e-07 0
+ 7.4074999999999996e-07 0
+ 7.4099999999999998e-07 0
+ 7.4125e-07 0
+ 7.4150000000000002e-07 0
+ 7.4175000000000003e-07 0
+ 7.4199999999999995e-07 0
+ 7.4224999999999997e-07 0
+ 7.4249999999999998e-07 0
+ 7.4275e-07 0
+ 7.4300000000000002e-07 0
+ 7.4325000000000004e-07 0
+ 7.4349999999999995e-07 0
+ 7.4374999999999997e-07 0
+ 7.4399999999999999e-07 0
+ 7.4425000000000001e-07 0
+ 7.4450000000000003e-07 0
+ 7.4475000000000005e-07 0
+ 7.4499999999999996e-07 0
+ 7.4524999999999998e-07 0
+ 7.455e-07 0
+ 7.4575000000000002e-07 0
+ 7.4600000000000004e-07 0
+ 7.4624999999999995e-07 0
+ 7.4649999999999997e-07 0
+ 7.4674999999999999e-07 0
+ 7.4700000000000001e-07 0
+ 7.4725000000000002e-07 0
+ 7.4750000000000004e-07 0
+ 7.4774999999999996e-07 0
+ 7.4799999999999997e-07 0
+ 7.4824999999999999e-07 0
+ 7.4850000000000001e-07 0
+ 7.4875000000000003e-07 0
+ 7.4900000000000005e-07 0
+ 7.4924999999999996e-07 0
+ 7.4949999999999998e-07 0
+ 7.4975e-07 0
+ 7.5000000000000002e-07 0
+ 7.5025000000000004e-07 0
+ 7.5049999999999995e-07 0
+ 7.5074999999999997e-07 0
+ 7.5099999999999999e-07 0
+ 7.5125000000000001e-07 0
+ 7.5150000000000003e-07 0
+ 7.5175000000000004e-07 0
+ 7.5199999999999996e-07 0
+ 7.5224999999999998e-07 0
+ 7.525e-07 0
+ 7.5275000000000001e-07 0
+ 7.5300000000000003e-07 0
+ 7.5325000000000005e-07 0
+ 7.5349999999999996e-07 0
+ 7.5374999999999998e-07 0
+ 7.54e-07 0
+ 7.5425000000000002e-07 0
+ 7.5450000000000004e-07 0
+ 7.5474999999999995e-07 0
+ 7.5499999999999997e-07 0
+ 7.5524999999999999e-07 0
+ 7.5550000000000001e-07 0
+ 7.5575000000000003e-07 0
+ 7.5600000000000005e-07 0
+ 7.5624999999999996e-07 0
+ 7.5649999999999998e-07 0
+ 7.5675e-07 0
+ 7.5700000000000002e-07 0
+ 7.5725000000000003e-07 0
+ 7.5749999999999995e-07 0
+ 7.5774999999999997e-07 0
+ 7.5799999999999998e-07 0
+ 7.5825e-07 0
+ 7.5850000000000002e-07 0
+ 7.5875000000000004e-07 0
+ 7.5899999999999995e-07 0
+ 7.5924999999999997e-07 0
+ 7.5949999999999999e-07 0
+ 7.5975000000000001e-07 0
+ 7.6000000000000003e-07 0
+ 7.6025000000000005e-07 0
+ 7.6049999999999996e-07 0
+ 7.6074999999999998e-07 0
+ 7.61e-07 0
+ 7.6125000000000002e-07 0
+ 7.6150000000000004e-07 0
+ 7.6174999999999995e-07 0
+ 7.6199999999999997e-07 0
+ 7.6224999999999999e-07 0
+ 7.6250000000000001e-07 0
+ 7.6275000000000002e-07 0
+ 7.6300000000000004e-07 0
+ 7.6324999999999996e-07 0
+ 7.6349999999999997e-07 0
+ 7.6374999999999999e-07 0
+ 7.6400000000000001e-07 0
+ 7.6425000000000003e-07 0
+ 7.6450000000000005e-07 0
+ 7.6474999999999996e-07 0
+ 7.6499999999999998e-07 0
+ 7.6525e-07 0
+ 7.6550000000000002e-07 0
+ 7.6575000000000004e-07 0
+ 7.6599999999999995e-07 0
+ 7.6624999999999997e-07 0
+ 7.6649999999999999e-07 0
+ 7.6675000000000001e-07 0
+ 7.6700000000000003e-07 0
+ 7.6725000000000004e-07 0
+ 7.6749999999999996e-07 0
+ 7.6774999999999998e-07 0
+ 7.6799999999999999e-07 0
+ 7.6825000000000001e-07 0
+ 7.6850000000000003e-07 0
+ 7.6875000000000005e-07 0
+ 7.6899999999999996e-07 0
+ 7.6924999999999998e-07 0
+ 7.695e-07 0
+ 7.6975000000000002e-07 0
+ 7.7000000000000004e-07 0
+ 7.7024999999999995e-07 0
+ 7.7049999999999997e-07 0
+ 7.7074999999999999e-07 0
+ 7.7100000000000001e-07 0
+ 7.7125000000000003e-07 0
+ 7.7150000000000005e-07 0
+ 7.7174999999999996e-07 0
+ 7.7199999999999998e-07 0
+ 7.7225e-07 0
+ 7.7250000000000002e-07 0
+ 7.7275000000000003e-07 0
+ 7.7300000000000005e-07 0
+ 7.7324999999999997e-07 0
+ 7.7349999999999998e-07 0
+ 7.7375e-07 0
+ 7.7400000000000002e-07 0
+ 7.7425000000000004e-07 0
+ 7.7449999999999995e-07 0
+ 7.7474999999999997e-07 0
+ 7.7499999999999999e-07 0
+ 7.7525000000000001e-07 0
+ 7.7550000000000003e-07 0
+ 7.7575000000000005e-07 0
+ 7.7599999999999996e-07 0
+ 7.7624999999999998e-07 0
+ 7.765e-07 0
+ 7.7675000000000002e-07 0
+ 7.7700000000000004e-07 0
+ 7.7724999999999995e-07 0
+ 7.7749999999999997e-07 0
+ 7.7774999999999999e-07 0
+ 7.7800000000000001e-07 0
+ 7.7825000000000002e-07 0
+ 7.7850000000000004e-07 0
+ 7.7874999999999996e-07 0
+ 7.7899999999999997e-07 0
+ 7.7924999999999999e-07 0
+ 7.7950000000000001e-07 0
+ 7.7975000000000003e-07 0
+ 7.8000000000000005e-07 0
+ 7.8024999999999996e-07 0
+ 7.8049999999999998e-07 0
+ 7.8075e-07 0
+ 7.8100000000000002e-07 0
+ 7.8125000000000004e-07 0
+ 7.8149999999999995e-07 0
+ 7.8174999999999997e-07 0
+ 7.8199999999999999e-07 0
+ 7.8225000000000001e-07 0
+ 7.8250000000000003e-07 0
+ 7.8275000000000004e-07 0
+ 7.8299999999999996e-07 0
+ 7.8324999999999998e-07 0
+ 7.8349999999999999e-07 0
+ 7.8375000000000001e-07 0
+ 7.8400000000000003e-07 0
+ 7.8425000000000005e-07 0
+ 7.8449999999999996e-07 0
+ 7.8474999999999998e-07 0
+ 7.85e-07 0
+ 7.8525000000000002e-07 0
+ 7.8550000000000004e-07 0
+ 7.8574999999999995e-07 0
+ 7.8599999999999997e-07 0
+ 7.8624999999999999e-07 0
+ 7.8650000000000001e-07 0
+ 7.8675000000000003e-07 0
+ 7.8700000000000005e-07 0
+ 7.8724999999999996e-07 0
+ 7.8749999999999998e-07 0
+ 7.8775e-07 0
+ 7.8800000000000002e-07 0
+ 7.8825000000000003e-07 0
+ 7.8850000000000005e-07 0
+ 7.8874999999999997e-07 0
+ 7.8899999999999998e-07 0
+ 7.8925e-07 0
+ 7.8950000000000002e-07 0
+ 7.8975000000000004e-07 0
+ 7.8999999999999995e-07 0
+ 7.9024999999999997e-07 0
+ 7.9049999999999999e-07 0
+ 7.9075000000000001e-07 0
+ 7.9100000000000003e-07 0
+ 7.9125000000000005e-07 0
+ 7.9149999999999996e-07 0
+ 7.9174999999999998e-07 0
+ 7.92e-07 0
+ 7.9225000000000002e-07 0
+ 7.9250000000000004e-07 0
+ 7.9274999999999995e-07 0
+ 7.9299999999999997e-07 0
+ 7.9324999999999999e-07 0
+ 7.935e-07 0
+ 7.9375000000000002e-07 0
+ 7.9400000000000004e-07 0
+ 7.9424999999999996e-07 0
+ 7.9449999999999997e-07 0
+ 7.9474999999999999e-07 0
+ 7.9500000000000001e-07 0
+ 7.9525000000000003e-07 0
+ 7.9550000000000005e-07 0
+ 7.9574999999999996e-07 0
+ 7.9599999999999998e-07 0
+ 7.9625e-07 0
+ 7.9650000000000002e-07 0
+ 7.9675000000000004e-07 0
+ 7.9699999999999995e-07 0
+ 7.9724999999999997e-07 0
+ 7.9749999999999999e-07 0
+ 7.9775000000000001e-07 0
+ 7.9800000000000003e-07 0
+ 7.9825000000000004e-07 0
+ 7.9849999999999996e-07 0
+ 7.9874999999999998e-07 0
+ 7.9899999999999999e-07 0
+ 7.9925000000000001e-07 0
+ 7.9950000000000003e-07 0
+ 7.9975000000000005e-07 0
+ 7.9999999999999996e-07 0
+ 8.0024999999999998e-07 0
+ 8.005e-07 0
+ 8.0075000000000002e-07 0
+ 8.0100000000000004e-07 0
+ 8.0124999999999995e-07 0
+ 8.0149999999999997e-07 0
+ 8.0174999999999999e-07 0
+ 8.0200000000000001e-07 0
+ 8.0225000000000003e-07 0
+ 8.0250000000000005e-07 0
+ 8.0274999999999996e-07 0
+ 8.0299999999999998e-07 0
+ 8.0325e-07 0
+ 8.0350000000000001e-07 0
+ 8.0375000000000003e-07 0
+ 8.0400000000000005e-07 0
+ 8.0424999999999997e-07 0
+ 8.0449999999999998e-07 0
+ 8.0475e-07 0
+ 8.0500000000000002e-07 0
+ 8.0525000000000004e-07 0
+ 8.0549999999999995e-07 0
+ 8.0574999999999997e-07 0
+ 8.0599999999999999e-07 0
+ 8.0625000000000001e-07 0
+ 8.0650000000000003e-07 0
+ 8.0675000000000005e-07 0
+ 8.0699999999999996e-07 0
+ 8.0724999999999998e-07 0
+ 8.075e-07 0
+ 8.0775000000000002e-07 0
+ 8.0800000000000004e-07 0
+ 8.0824999999999995e-07 0
+ 8.0849999999999997e-07 0
+ 8.0874999999999999e-07 0
+ 8.09e-07 0
+ 8.0925000000000002e-07 0
+ 8.0950000000000004e-07 0
+ 8.0974999999999996e-07 0
+ 8.0999999999999997e-07 0
+ 8.1024999999999999e-07 0
+ 8.1050000000000001e-07 0
+ 8.1075000000000003e-07 0
+ 8.1100000000000005e-07 0
+ 8.1124999999999996e-07 0
+ 8.1149999999999998e-07 0
+ 8.1175e-07 0
+ 8.1200000000000002e-07 0
+ 8.1225000000000004e-07 0
+ 8.1249999999999995e-07 0
+ 8.1274999999999997e-07 0
+ 8.1299999999999999e-07 0
+ 8.1325000000000001e-07 0
+ 8.1350000000000003e-07 0
+ 8.1375000000000004e-07 0
+ 8.1399999999999996e-07 0
+ 8.1424999999999998e-07 0
+ 8.1449999999999999e-07 0
+ 8.1475000000000001e-07 0
+ 8.1500000000000003e-07 0
+ 8.1525000000000005e-07 0
+ 8.1549999999999996e-07 0
+ 8.1574999999999998e-07 0
+ 8.16e-07 0
+ 8.1625000000000002e-07 0
+ 8.1650000000000004e-07 0
+ 8.1674999999999995e-07 0
+ 8.1699999999999997e-07 0
+ 8.1724999999999999e-07 0
+ 8.1750000000000001e-07 0
+ 8.1775000000000003e-07 0
+ 8.1800000000000005e-07 0
+ 8.1824999999999996e-07 0
+ 8.1849999999999998e-07 0
+ 8.1875e-07 0
+ 8.1900000000000001e-07 0
+ 8.1925000000000003e-07 0
+ 8.1950000000000005e-07 0
+ 8.1974999999999997e-07 0
+ 8.1999999999999998e-07 0
+ 8.2025e-07 0
+ 8.2050000000000002e-07 0
+ 8.2075000000000004e-07 0
+ 8.2099999999999995e-07 0
+ 8.2124999999999997e-07 0
+ 8.2149999999999999e-07 0
+ 8.2175000000000001e-07 0
+ 8.2200000000000003e-07 0
+ 8.2225000000000005e-07 0
+ 8.2249999999999996e-07 0
+ 8.2274999999999998e-07 0
+ 8.23e-07 0
+ 8.2325000000000002e-07 0
+ 8.2350000000000004e-07 0
+ 8.2374999999999995e-07 0
+ 8.2399999999999997e-07 0
+ 8.2424999999999999e-07 0
+ 8.245e-07 0
+ 8.2475000000000002e-07 0
+ 8.2500000000000004e-07 0
+ 8.2524999999999995e-07 0
+ 8.2549999999999997e-07 0
+ 8.2574999999999999e-07 0
+ 8.2600000000000001e-07 0
+ 8.2625000000000003e-07 0
+ 8.2650000000000005e-07 0
+ 8.2674999999999996e-07 0
+ 8.2699999999999998e-07 0
+ 8.2725e-07 0
+ 8.2750000000000002e-07 0
+ 8.2775000000000004e-07 0
+ 8.2799999999999995e-07 0
+ 8.2824999999999997e-07 0
+ 8.2849999999999999e-07 0
+ 8.2875000000000001e-07 0
+ 8.2900000000000002e-07 0
+ 8.2925000000000004e-07 0
+ 8.2949999999999996e-07 0
+ 8.2974999999999998e-07 0
+ 8.2999999999999999e-07 0
+ 8.3025000000000001e-07 0
+ 8.3050000000000003e-07 0
+ 8.3075000000000005e-07 0
+ 8.3099999999999996e-07 0
+ 8.3124999999999998e-07 0
+ 8.315e-07 0
+ 8.3175000000000002e-07 0
+ 8.3200000000000004e-07 0
+ 8.3203000000000002e-07 0
+ 8.3224999999999995e-07 0
+ 8.3249999999999997e-07 0
+ 8.3274999999999999e-07 0
+ 8.3300000000000001e-07 0
+ 8.3325000000000003e-07 0
+ 8.3350000000000005e-07 0
+ 8.3374999999999996e-07 0
+ 8.3399999999999998e-07 0
+ 8.3425e-07 0
+ 8.3450000000000001e-07 0
+ 8.3475000000000003e-07 0
+ 8.3500000000000005e-07 0
+ 8.3524999999999997e-07 0
+ 8.3549999999999998e-07 0
+ 8.3575e-07 0
+ 8.3600000000000002e-07 0
+ 8.3625000000000004e-07 0
+ 8.3649999999999995e-07 0
+ 8.3674999999999997e-07 0
+ 8.3699999999999999e-07 0
+ 8.3725000000000001e-07 0
+ 8.3750000000000003e-07 0
+ 8.3775000000000005e-07 0
+ 8.3799999999999996e-07 0
+ 8.3824999999999998e-07 0
+ 8.385e-07 0
+ 8.3875000000000002e-07 0
+ 8.3900000000000004e-07 0
+ 8.3906249999999996e-07 0
+ 8.3924999999999995e-07 0
+ 8.3949999999999997e-07 0
+ 8.3974999999999999e-07 0
+ 8.4e-07 0
+ 8.4025000000000002e-07 0
+ 8.4050000000000004e-07 0
+ 8.40625e-07 0
+ 8.4074999999999995e-07 0
+ 8.4099999999999997e-07 0
+ 8.4124999999999999e-07 0
+ 8.4150000000000001e-07 0
+ 8.4175000000000003e-07 0
+ 8.4200000000000005e-07 0
+ 8.4218750000000004e-07 0
+ 8.4224999999999996e-07 0
+ 8.4249999999999998e-07 0
+ 8.4275e-07 0
+ 8.4300000000000002e-07 0
+ 8.4325000000000004e-07 0
+ 8.4349999999999995e-07 0
+ 8.4374999999999997e-07 0
+ 8.4399999999999999e-07 0
+ 8.4425000000000001e-07 0
+ 8.4450000000000002e-07 0
+ 8.4475000000000004e-07 0
+ 8.4499999999999996e-07 0
+ 8.4524999999999998e-07 0
+ 8.4531250000000001e-07 0
+ 8.4549999999999999e-07 0
+ 8.4575000000000001e-07 0
+ 8.4600000000000003e-07 0
+ 8.4625000000000005e-07 0
+ 8.4649999999999996e-07 0
+ 8.4674999999999998e-07 0
+ 8.4687500000000004e-07 0
+ 8.47e-07 0
+ 8.4725000000000002e-07 0
+ 8.4750000000000004e-07 0
+ 8.4774999999999995e-07 0
+ 8.4799999999999997e-07 0
+ 8.4824999999999999e-07 0
+ 8.4843749999999998e-07 0
+ 8.4850000000000001e-07 0
+ 8.4875000000000003e-07 0
+ 8.4900000000000005e-07 0
+ 8.4924999999999996e-07 0
+ 8.4949999999999998e-07 0
+ 8.4975e-07 0
+ 8.5000000000000001e-07 0
+ 8.5025000000000003e-07 0
+ 8.5050000000000005e-07 0
+ 8.5074999999999996e-07 0
+ 8.5099999999999998e-07 0
+ 8.5125e-07 0
+ 8.5150000000000002e-07 0
+ 8.5156250000000005e-07 0
+ 8.5175000000000004e-07 0
+ 8.5199999999999995e-07 0
+ 8.5224999999999997e-07 0
+ 8.5249999999999999e-07 0
+ 8.5275000000000001e-07 0
+ 8.5300000000000003e-07 0
+ 8.5312499999999998e-07 0
+ 8.5325000000000005e-07 0
+ 8.5349999999999996e-07 0
+ 8.5374999999999998e-07 0
+ 8.54e-07 0
+ 8.5425000000000002e-07 0
+ 8.5450000000000003e-07 0
+ 8.5468750000000002e-07 0
+ 8.5474999999999995e-07 0
+ 8.5499999999999997e-07 0
+ 8.5524999999999999e-07 0
+ 8.555e-07 0
+ 8.5575000000000002e-07 0
+ 8.5600000000000004e-07 0
+ 8.5624999999999995e-07 0
+ 8.5649999999999997e-07 0
+ 8.5674999999999999e-07 0
+ 8.5700000000000001e-07 0
+ 8.5725000000000003e-07 0
+ 8.5750000000000005e-07 0
+ 8.5774999999999996e-07 0
+ 8.5781249999999999e-07 0
+ 8.5799999999999998e-07 0
+ 8.5825e-07 0
+ 8.5850000000000002e-07 0
+ 8.5875000000000004e-07 0
+ 8.5899999999999995e-07 0
+ 8.5924999999999997e-07 0
+ 8.5937500000000003e-07 0
+ 8.5949999999999999e-07 0
+ 8.5975000000000001e-07 0
+ 8.6000000000000002e-07 0
+ 8.6025000000000004e-07 0
+ 8.6049999999999996e-07 0
+ 8.6074999999999998e-07 0
+ 8.6093749999999996e-07 0
+ 8.6099999999999999e-07 0
+ 8.6125000000000001e-07 0
+ 8.6150000000000003e-07 0
+ 8.6175000000000005e-07 0
+ 8.6199999999999996e-07 0
+ 8.6224999999999998e-07 0
+ 8.625e-07 0
+ 8.6275000000000002e-07 0
+ 8.6300000000000004e-07 0
+ 8.6324999999999995e-07 0
+ 8.6349999999999997e-07 0
+ 8.6374999999999999e-07 0
+ 8.6400000000000001e-07 0
+ 8.6406250000000004e-07 0
+ 8.6425000000000003e-07 0
+ 8.6450000000000005e-07 0
+ 8.6474999999999996e-07 0
+ 8.6499999999999998e-07 0
+ 8.6525e-07 0
+ 8.6550000000000001e-07 0
+ 8.6562499999999997e-07 0
+ 8.6575000000000003e-07 0
+ 8.6600000000000005e-07 0
+ 8.6624999999999996e-07 0
+ 8.6649999999999998e-07 0
+ 8.6675e-07 0
+ 8.6700000000000002e-07 0
+ 8.6718750000000001e-07 0
+ 8.6725000000000004e-07 0
+ 8.6749999999999995e-07 0
+ 8.6774999999999997e-07 0
+ 8.6799999999999999e-07 0
+ 8.6825000000000001e-07 0
+ 8.6850000000000003e-07 0
+ 8.6875000000000005e-07 0
+ 8.6899999999999996e-07 0
+ 8.6924999999999998e-07 0
+ 8.695e-07 0
+ 8.6975000000000002e-07 0
+ 8.7000000000000003e-07 0
+ 8.7024999999999995e-07 0
+ 8.7031249999999998e-07 0
+ 8.7049999999999997e-07 0
+ 8.7074999999999999e-07 0
+ 8.71e-07 0
+ 8.7125000000000002e-07 0
+ 8.7150000000000004e-07 0
+ 8.7174999999999995e-07 0
+ 8.7187500000000002e-07 0
+ 8.7199999999999997e-07 0
+ 8.7224999999999999e-07 0
+ 8.7250000000000001e-07 0
+ 8.7275000000000003e-07 0
+ 8.7300000000000005e-07 0
+ 8.7324999999999996e-07 0
+ 8.7343749999999995e-07 0
+ 8.7349999999999998e-07 0
+ 8.7375e-07 0
+ 8.7400000000000002e-07 0
+ 8.7425000000000004e-07 0
+ 8.7449999999999995e-07 0
+ 8.7474999999999997e-07 0
+ 8.7499999999999999e-07 0
+ 8.7525000000000001e-07 0
+ 8.7550000000000002e-07 0
+ 8.7575000000000004e-07 0
+ 8.7599999999999996e-07 0
+ 8.7624999999999997e-07 0
+ 8.7649999999999999e-07 0
+ 8.7656250000000002e-07 0
+ 8.7675000000000001e-07 0
+ 8.7700000000000003e-07 0
+ 8.7725000000000005e-07 0
+ 8.7749999999999996e-07 0
+ 8.7774999999999998e-07 0
+ 8.78e-07 0
+ 8.7812499999999996e-07 0
+ 8.7825000000000002e-07 0
+ 8.7850000000000004e-07 0
+ 8.7874999999999995e-07 0
+ 8.7899999999999997e-07 0
+ 8.7924999999999999e-07 0
+ 8.7950000000000001e-07 0
+ 8.7968749999999999e-07 0
+ 8.7975000000000003e-07 0
+ 8.8000000000000004e-07 0
+ 8.8024999999999996e-07 0
+ 8.8049999999999998e-07 0
+ 8.8075e-07 0
+ 8.8100000000000001e-07 0
+ 8.8125000000000003e-07 0
+ 8.8150000000000005e-07 0
+ 8.8174999999999996e-07 0
+ 8.8199999999999998e-07 0
+ 8.8202999999999996e-07 0
+ 8.8225e-07 0
+ 8.8250000000000002e-07 0
+ 8.8275000000000004e-07 0
+ 8.8281249999999997e-07 0
+ 8.8299999999999995e-07 0
+ 8.8324999999999997e-07 0
+ 8.8349999999999999e-07 0
+ 8.8375000000000001e-07 0
+ 8.8400000000000003e-07 0
+ 8.8425000000000005e-07 0
+ 8.84375e-07 0
+ 8.8449999999999996e-07 0
+ 8.8474999999999998e-07 0
+ 8.85e-07 0
+ 8.8525000000000002e-07 0
+ 8.8550000000000003e-07 0
+ 8.8574999999999995e-07 0
+ 8.8593750000000004e-07 0
+ 8.8599999999999997e-07 0
+ 8.8624999999999999e-07 0
+ 8.865e-07 0
+ 8.8675000000000002e-07 0
+ 8.8700000000000004e-07 0
+ 8.8724999999999995e-07 0
+ 8.8749999999999997e-07 0
+ 8.8774999999999999e-07 0
+ 8.8800000000000001e-07 0
+ 8.8825000000000003e-07 0
+ 8.8850000000000005e-07 0
+ 8.8874999999999996e-07 0
+ 8.8899999999999998e-07 0
+ 8.8906250000000001e-07 0
+ 8.8925e-07 0
+ 8.8950000000000002e-07 0
+ 8.8975000000000004e-07 0
+ 8.8999999999999995e-07 0
+ 8.9024999999999997e-07 0
+ 8.9049999999999999e-07 0
+ 8.9062500000000005e-07 0
+ 8.9075000000000001e-07 0
+ 8.9100000000000002e-07 0
+ 8.9125000000000004e-07 0
+ 8.9149999999999996e-07 0
+ 8.9174999999999997e-07 0
+ 8.9199999999999999e-07 0
+ 8.9218749999999998e-07 0
+ 8.9225000000000001e-07 0
+ 8.9250000000000003e-07 0
+ 8.9275000000000005e-07 0
+ 8.9299999999999996e-07 0
+ 8.9305799999999998e-07 0
+ 8.9324999999999998e-07 0
+ 8.935e-07 0
+ 8.9375000000000002e-07 0
+ 8.9400000000000004e-07 0
+ 8.9424999999999995e-07 0
+ 8.9449999999999997e-07 0
+ 8.9474999999999999e-07 0
+ 8.9500000000000001e-07 0
+ 8.9525000000000003e-07 0
+ 8.9531249999999995e-07 0
+ 8.9550000000000004e-07 0
+ 8.9574999999999996e-07 0
+ 8.9599999999999998e-07 0
+ 8.9625e-07 0
+ 8.9650000000000001e-07 0
+ 8.9675000000000003e-07 0
+ 8.9687499999999999e-07 0
+ 8.9700000000000005e-07 0
+ 8.9724999999999996e-07 0
+ 8.9749999999999998e-07 0
+ 8.9775e-07 0
+ 8.9800000000000002e-07 0
+ 8.9825000000000004e-07 0
+ 8.9843750000000003e-07 0
+ 8.9849999999999995e-07 0
+ 8.9874999999999997e-07 0
+ 8.9899999999999999e-07 0
+ 8.9925000000000001e-07 0
+ 8.9950000000000003e-07 0
+ 8.9975000000000005e-07 0
+ 8.9999999999999996e-07 0
+ 9.0024999999999998e-07 0
+ 9.005e-07 0
+ 9.0075000000000002e-07 0
+ 9.0100000000000003e-07 0
+ 9.0124999999999995e-07 0
+ 9.0149999999999997e-07 0
+ 9.015625e-07 0
+ 9.0174999999999998e-07 0
+ 9.02e-07 0
+ 9.0225000000000002e-07 0
+ 9.0250000000000004e-07 0
+ 9.0274999999999995e-07 0
+ 9.0299999999999997e-07 0
+ 9.0312500000000004e-07 0
+ 9.0324999999999999e-07 0
+ 9.0350000000000001e-07 0
+ 9.0375000000000003e-07 0
+ 9.0400000000000005e-07 0
+ 9.0424999999999996e-07 0
+ 9.0449999999999998e-07 0
+ 9.0468749999999997e-07 0
+ 9.0475e-07 0
+ 9.0500000000000002e-07 0
+ 9.0525000000000004e-07 0
+ 9.0549999999999995e-07 0
+ 9.0574999999999997e-07 0
+ 9.0599999999999999e-07 0
+ 9.0625000000000001e-07 0
+ 9.0650000000000002e-07 0
+ 9.0675000000000004e-07 0
+ 9.0699999999999996e-07 0
+ 9.0724999999999997e-07 0
+ 9.0749999999999999e-07 0
+ 9.0775000000000001e-07 0
+ 9.0781250000000004e-07 0
+ 9.0800000000000003e-07 0
+ 9.0825000000000005e-07 0
+ 9.0849999999999996e-07 0
+ 9.0874999999999998e-07 0
+ 9.09e-07 0
+ 9.0925000000000002e-07 0
+ 9.0937499999999998e-07 0
+ 9.0950000000000004e-07 0
+ 9.0974999999999995e-07 0
+ 9.0999999999999997e-07 0
+ 9.1024999999999999e-07 0
+ 9.1050000000000001e-07 0
+ 9.1075000000000003e-07 0
+ 9.1093750000000001e-07 0
+ 9.1100000000000004e-07 0
+ 9.1124999999999996e-07 0
+ 9.1149999999999998e-07 0
+ 9.1175e-07 0
+ 9.1200000000000001e-07 0
+ 9.1225000000000003e-07 0
+ 9.1250000000000005e-07 0
+ 9.1274999999999996e-07 0
+ 9.1299999999999998e-07 0
+ 9.1325e-07 0
+ 9.1350000000000002e-07 0
+ 9.1375000000000004e-07 0
+ 9.1399999999999995e-07 0
+ 9.1406249999999998e-07 0
+ 9.1424999999999997e-07 0
+ 9.1449999999999999e-07 0
+ 9.1475000000000001e-07 0
+ 9.1500000000000003e-07 0
+ 9.1525000000000005e-07 0
+ 9.1549999999999996e-07 0
+ 9.1562500000000002e-07 0
+ 9.1574999999999998e-07 0
+ 9.16e-07 0
+ 9.1625000000000002e-07 0
+ 9.1650000000000003e-07 0
+ 9.1674999999999995e-07 0
+ 9.1699999999999997e-07 0
+ 9.1718749999999995e-07 0
+ 9.1724999999999998e-07 0
+ 9.175e-07 0
+ 9.1775000000000002e-07 0
+ 9.1800000000000004e-07 0
+ 9.1824999999999995e-07 0
+ 9.1849999999999997e-07 0
+ 9.1874999999999999e-07 0
+ 9.1900000000000001e-07 0
+ 9.1925000000000003e-07 0
+ 9.1950000000000005e-07 0
+ 9.1974999999999996e-07 0
+ 9.1999999999999998e-07 0
+ 9.2025e-07 0
+ 9.2031250000000003e-07 0
+ 9.2050000000000002e-07 0
+ 9.2075000000000004e-07 0
+ 9.2099999999999995e-07 0
+ 9.2124999999999997e-07 0
+ 9.2149999999999999e-07 0
+ 9.2175000000000001e-07 0
+ 9.2187499999999996e-07 0
+ 9.2200000000000002e-07 0
+ 9.2225000000000004e-07 0
+ 9.2249999999999996e-07 0
+ 9.2274999999999997e-07 0
+ 9.2299999999999999e-07 0
+ 9.2325000000000001e-07 0
+ 9.234375e-07 0
+ 9.2350000000000003e-07 0
+ 9.2375000000000005e-07 0
+ 9.2399999999999996e-07 0
+ 9.2424999999999998e-07 0
+ 9.245e-07 0
+ 9.2475000000000002e-07 0
+ 9.2500000000000004e-07 0
+ 9.2524999999999995e-07 0
+ 9.2549999999999997e-07 0
+ 9.2574999999999999e-07 0
+ 9.2600000000000001e-07 0
+ 9.2625000000000003e-07 0
+ 9.2650000000000004e-07 0
+ 9.2656249999999997e-07 0
+ 9.2674999999999996e-07 0
+ 9.2699999999999998e-07 0
+ 9.2724999999999999e-07 0
+ 9.2750000000000001e-07 0
+ 9.2775000000000003e-07 0
+ 9.2800000000000005e-07 0
+ 9.2812500000000001e-07 0
+ 9.2824999999999996e-07 0
+ 9.2849999999999998e-07 0
+ 9.2875e-07 0
+ 9.2900000000000002e-07 0
+ 9.2925000000000004e-07 0
+ 9.2949999999999995e-07 0
+ 9.2968750000000005e-07 0
+ 9.2974999999999997e-07 0
+ 9.2999999999999999e-07 0
+ 9.3025000000000001e-07 0
+ 9.3050000000000003e-07 0
+ 9.3075000000000005e-07 0
+ 9.3099999999999996e-07 0
+ 9.3124999999999998e-07 0
+ 9.315e-07 0
+ 9.3175000000000002e-07 0
+ 9.3200000000000003e-07 0
+ 9.3225000000000005e-07 0
+ 9.3249999999999997e-07 0
+ 9.3274999999999998e-07 0
+ 9.3281250000000002e-07 0
+ 9.33e-07 0
+ 9.3325000000000002e-07 0
+ 9.3350000000000004e-07 0
+ 9.3374999999999995e-07 0
+ 9.3399999999999997e-07 0
+ 9.3424999999999999e-07 0
+ 9.3437499999999995e-07 0
+ 9.3450000000000001e-07 0
+ 9.3475000000000003e-07 0
+ 9.3500000000000005e-07 0
+ 9.3524999999999996e-07 0
+ 9.3549999999999998e-07 0
+ 9.3575e-07 0
+ 9.3593749999999999e-07 0
+ 9.3600000000000002e-07 0
+ 9.3625000000000004e-07 0
+ 9.3649999999999995e-07 0
+ 9.3674999999999997e-07 0
+ 9.3699999999999999e-07 0
+ 9.3725e-07 0
+ 9.3750000000000002e-07 0
+ 9.3775000000000004e-07 0
+ 9.3799999999999996e-07 0
+ 9.3824999999999997e-07 0
+ 9.3849999999999999e-07 0
+ 9.3875000000000001e-07 0
+ 9.3900000000000003e-07 0
+ 9.3906249999999996e-07 0
+ 9.3925000000000005e-07 0
+ 9.3949999999999996e-07 0
+ 9.3974999999999998e-07 0
+ 9.4e-07 0
+ 9.4025000000000002e-07 0
+ 9.4050000000000004e-07 0
+ 9.4062499999999999e-07 0
+ 9.4074999999999995e-07 0
+ 9.4099999999999997e-07 0
+ 9.4124999999999999e-07 0
+ 9.4150000000000001e-07 0
+ 9.4175000000000003e-07 0
+ 9.4200000000000004e-07 0
+ 9.4218750000000003e-07 0
+ 9.4224999999999996e-07 0
+ 9.4249999999999998e-07 0
+ 9.4274999999999999e-07 0
+ 9.4300000000000001e-07 0
+ 9.4325000000000003e-07 0
+ 9.4350000000000005e-07 0
+ 9.4374999999999996e-07 0
+ 9.4399999999999998e-07 0
+ 9.4425e-07 0
+ 9.4450000000000002e-07 0
+ 9.4453e-07 0
+ 9.4475000000000004e-07 0
+ 9.4499999999999995e-07 0
+ 9.4524999999999997e-07 0
+ 9.453125e-07 0
+ 9.4549999999999999e-07 0
+ 9.4575000000000001e-07 0
+ 9.4600000000000003e-07 0
+ 9.4625000000000005e-07 0
+ 9.4649999999999996e-07 0
+ 9.4674999999999998e-07 0
+ 9.4687500000000004e-07 0
+ 9.47e-07 0
+ 9.4725000000000002e-07 0
+ 9.4750000000000003e-07 0
+ 9.4775000000000005e-07 0
+ 9.4799999999999997e-07 0
+ 9.4824999999999998e-07 0
+ 9.4843749999999997e-07 0
+ 9.485e-07 0
+ 9.4875000000000002e-07 0
+ 9.4900000000000004e-07 0
+ 9.4924999999999995e-07 0
+ 9.4949999999999997e-07 0
+ 9.4974999999999999e-07 0
+ 9.5000000000000001e-07 0
+ 9.5025000000000003e-07 0
+ 9.5050000000000005e-07 0
+ 9.5074999999999996e-07 0
+ 9.5099999999999998e-07 0
+ 9.5125e-07 0
+ 9.5150000000000002e-07 0
+ 9.5156250000000005e-07 0
+ 9.5175000000000004e-07 0
+ 9.5199999999999995e-07 0
+ 9.5224999999999997e-07 0
+ 9.5249999999999999e-07 0
+ 9.5275e-07 0
+ 9.5300000000000002e-07 0
+ 9.5312499999999998e-07 0
+ 9.5325000000000004e-07 0
+ 9.5349999999999996e-07 0
+ 9.5374999999999997e-07 0
+ 9.540000000000001e-07 0
+ 9.5425000000000001e-07 0
+ 9.5449999999999992e-07 0
+ 9.5468749999999991e-07 0
+ 9.5475000000000005e-07 0
+ 9.5499999999999996e-07 0
+ 9.5525000000000009e-07 0
+ 9.555e-07 0
+ 9.5555799999999991e-07 0
+ 9.5574999999999991e-07 0
+ 9.5600000000000004e-07 0
+ 9.5624999999999995e-07 0
+ 9.5650000000000007e-07 0
+ 9.5674999999999999e-07 0
+ 9.569999999999999e-07 0
+ 9.5725000000000003e-07 0
+ 9.5749999999999994e-07 0
+ 9.5775000000000006e-07 0
+ 9.5781249999999999e-07 0
+ 9.5799999999999998e-07 0
+ 9.582500000000001e-07 0
+ 9.5850000000000001e-07 0
+ 9.5874999999999993e-07 0
+ 9.5900000000000005e-07 0
+ 9.5924999999999996e-07 0
+ 9.5937500000000003e-07 0
+ 9.5950000000000009e-07 0
+ 9.5975e-07 0
+ 9.5999999999999991e-07 0
+ 9.6025000000000004e-07 0
+ 9.6049999999999995e-07 0
+ 9.6075000000000008e-07 0
+ 9.6080900000000001e-07 0
+ 9.6093750000000006e-07 0
+ 9.6099999999999999e-07 0
+ 9.612499999999999e-07 0
+ 9.6130300000000009e-07 0
+ 9.6150000000000003e-07 0
+ 9.6174999999999994e-07 0
+ 9.6200000000000006e-07 0
+ 9.6224999999999998e-07 0
+ 9.625000000000001e-07 0
+ 9.6275000000000001e-07 0
+ 9.6299999999999993e-07 0
+ 9.6325000000000005e-07 0
+ 9.6349999999999997e-07 0
+ 9.6375000000000009e-07 0
+ 9.64e-07 0
+ 9.6406249999999993e-07 0
+ 9.6424999999999992e-07 0
+ 9.6450000000000004e-07 0
+ 9.6474999999999995e-07 0
+ 9.6500000000000008e-07 0
+ 9.6524999999999999e-07 0
+ 9.654999999999999e-07 0
+ 9.6562499999999997e-07 0
+ 9.6575000000000003e-07 0
+ 9.6599999999999994e-07 0
+ 9.6625000000000007e-07 0
+ 9.6649999999999998e-07 0
+ 9.667500000000001e-07 0
+ 9.6700000000000002e-07 0
+ 9.671875e-07 0
+ 9.6724999999999993e-07 0
+ 9.6750000000000005e-07 0
+ 9.6774999999999997e-07 0
+ 9.6800000000000009e-07 0
+ 9.6825e-07 0
+ 9.6849999999999992e-07 0
+ 9.6875000000000004e-07 0
+ 9.6899999999999996e-07 0
+ 9.6925000000000008e-07 0
+ 9.6949999999999999e-07 0
+ 9.6974999999999991e-07 0
+ 9.7000000000000003e-07 0
+ 9.7024999999999994e-07 0
+ 9.7031250000000008e-07 0
+ 9.7050000000000007e-07 0
+ 9.7074999999999998e-07 0
+ 9.7100000000000011e-07 0
+ 9.7125000000000002e-07 0
+ 9.7149999999999993e-07 0
+ 9.7175000000000006e-07 0
+ 9.7187499999999991e-07 0
+ 9.7199999999999997e-07 0
+ 9.7225000000000009e-07 0
+ 9.7250000000000001e-07 0
+ 9.7274999999999992e-07 0
+ 9.7300000000000004e-07 0
+ 9.7324999999999996e-07 0
+ 9.7343749999999994e-07 0
+ 9.7350000000000008e-07 0
+ 9.7374999999999999e-07 0
+ 9.7399999999999991e-07 0
+ 9.7425000000000003e-07 0
+ 9.7449999999999994e-07 0
+ 9.7475000000000007e-07 0
+ 9.7499999999999998e-07 0
+ 9.752499999999999e-07 0
+ 9.7550000000000002e-07 0
+ 9.7574999999999993e-07 0
+ 9.7600000000000006e-07 0
+ 9.7624999999999997e-07 0
+ 9.765000000000001e-07 0
+ 9.7656250000000002e-07 0
+ 9.7675000000000001e-07 0
+ 9.7699999999999992e-07 0
+ 9.7725000000000005e-07 0
+ 9.7749999999999996e-07 0
+ 9.7775000000000008e-07 0
+ 9.78e-07 0
+ 9.7812500000000006e-07 0
+ 9.7824999999999991e-07 0
+ 9.7850000000000003e-07 0
+ 9.7874999999999995e-07 0
+ 9.7900000000000007e-07 0
+ 9.7924999999999998e-07 0
+ 9.794999999999999e-07 0
+ 9.796875000000001e-07 0
+ 9.7975000000000002e-07 0
+ 9.7999999999999993e-07 0
+ 9.8025000000000006e-07 0
+ 9.8049999999999997e-07 0
+ 9.807500000000001e-07 0
+ 9.8100000000000001e-07 0
+ 9.8124999999999992e-07 0
+ 9.8150000000000005e-07 0
+ 9.8174999999999996e-07 0
+ 9.8200000000000008e-07 0
+ 9.8225e-07 0
+ 9.8249999999999991e-07 0
+ 9.8275000000000004e-07 0
+ 9.8281249999999996e-07 0
+ 9.8299999999999995e-07 0
+ 9.8325000000000007e-07 0
+ 9.8349999999999999e-07 0
+ 9.837499999999999e-07 0
+ 9.8400000000000002e-07 0
+ 9.8424999999999994e-07 0
+ 9.84375e-07 0
+ 9.8450000000000006e-07 0
+ 9.8474999999999997e-07 0
+ 9.850000000000001e-07 0
+ 9.8525000000000001e-07 0
+ 9.8549999999999992e-07 0
+ 9.8575000000000005e-07 0
+ 9.8593750000000004e-07 0
+ 9.8599999999999996e-07 0
+ 9.8625000000000009e-07 0
+ 9.865e-07 0
+ 9.8674999999999991e-07 0
+ 9.8700000000000004e-07 0
+ 9.8724999999999995e-07 0
+ 9.8750000000000007e-07 0
+ 9.8774999999999999e-07 0
+ 9.879999999999999e-07 0
+ 9.8825000000000002e-07 0
+ 9.8849999999999994e-07 0
+ 9.8875000000000006e-07 0
+ 9.8899999999999998e-07 0
+ 9.890624999999999e-07 0
+ 9.892500000000001e-07 0
+ 9.8950000000000001e-07 0
+ 9.8974999999999993e-07 0
+ 9.9000000000000005e-07 0
+ 9.9024999999999996e-07 0
+ 9.9050000000000009e-07 0
+ 9.9062499999999994e-07 0
+ 9.9075e-07 0
+ 9.9099999999999991e-07 0
+ 9.9125000000000004e-07 0
+ 9.9149999999999995e-07 0
+ 9.9175000000000008e-07 0
+ 9.9199999999999999e-07 0
+ 9.9218749999999998e-07 0
+ 9.922499999999999e-07 0
+ 9.9250000000000003e-07 0
+ 9.9274999999999994e-07 0
+ 9.9300000000000006e-07 0
+ 9.9324999999999998e-07 0
+ 9.935000000000001e-07 0
+ 9.9375000000000001e-07 0
+ 9.9399999999999993e-07 0
+ 9.9425000000000005e-07 0
+ 9.9449999999999997e-07 0
+ 9.9475000000000009e-07 0
+ 9.95e-07 0
+ 9.9524999999999992e-07 0
+ 9.9531250000000005e-07 0
+ 9.9550000000000004e-07 0
+ 9.9574999999999995e-07 0
+ 9.9600000000000008e-07 0
+ 9.9624999999999999e-07 0
+ 9.964999999999999e-07 0
+ 9.9675000000000003e-07 0
+ 9.9687500000000009e-07 0
+ 9.9699999999999994e-07 0
+ 9.9725000000000007e-07 0
+ 9.9749999999999998e-07 0
+ 9.977500000000001e-07 0
+ 9.9800000000000002e-07 0
+ 9.9824999999999993e-07 0
+ 9.9843749999999992e-07 0
+ 9.9850000000000005e-07 0
+ 9.9874999999999997e-07 0
+ 9.9900000000000009e-07 0
+ 9.9925e-07 0
+ 9.9949999999999992e-07 0
+ 9.9975000000000004e-07 0
+ 9.9999999999999995e-07 0
+ 1.0002500000000001e-06 0
+ 1.0005e-06 0
+ 1.0007499999999999e-06 0
+ 1.001e-06 0
+ 1.0012499999999999e-06 0
+ 1.0015000000000001e-06 0
+ 1.0015625e-06 0
+ 1.00175e-06 0
+ 1.0020000000000001e-06 0
+ 1.00225e-06 0
+ 1.0024999999999999e-06 0
+ 1.0027500000000001e-06 0
+ 1.003e-06 0
+ 1.003125e-06 0
+ 1.0032500000000001e-06 0
+ 1.0035e-06 0
+ 1.0037499999999999e-06 0
+ 1.004e-06 0
+ 1.00425e-06 0
+ 1.0045000000000001e-06 0
+ 1.0046875000000001e-06 0
+ 1.00475e-06 0
+ 1.0049999999999999e-06 0
+ 1.00525e-06 0
+ 1.0054999999999999e-06 0
+ 1.0057500000000001e-06 0
+ 1.006e-06 0
+ 1.0062499999999999e-06 0
+ 1.0065e-06 0
+ 1.0067499999999999e-06 0
+ 1.0070000000000001e-06 0
+ 1.00725e-06 0
+ 1.0075000000000001e-06 0
+ 1.00775e-06 0
+ 1.0078124999999999e-06 0
+ 1.0079999999999999e-06 0
+ 1.00825e-06 0
+ 1.0085e-06 0
+ 1.0087500000000001e-06 0
+ 1.009e-06 0
+ 1.0092499999999999e-06 0
+ 1.009375e-06 0
+ 1.0095e-06 0
+ 1.0097499999999999e-06 0
+ 1.0100000000000001e-06 0
+ 1.01025e-06 0
+ 1.0104999999999999e-06 0
+ 1.01075e-06 0
+ 1.0109375e-06 0
+ 1.0109999999999999e-06 0
+ 1.0112500000000001e-06 0
+ 1.0115e-06 0
+ 1.0117500000000001e-06 0
+ 1.012e-06 0
+ 1.0122499999999999e-06 0
+ 1.0125e-06 0
+ 1.01275e-06 0
+ 1.0130000000000001e-06 0
+ 1.01325e-06 0
+ 1.0134999999999999e-06 0
+ 1.01375e-06 0
+ 1.0139999999999999e-06 0
+ 1.0140625000000001e-06 0
+ 1.0142500000000001e-06 0
+ 1.0145e-06 0
+ 1.0147499999999999e-06 0
+ 1.015e-06 0
+ 1.0152499999999999e-06 0
+ 1.0155000000000001e-06 0
+ 1.0156249999999999e-06 0
+ 1.01575e-06 0
+ 1.0160000000000001e-06 0
+ 1.01625e-06 0
+ 1.0164999999999999e-06 0
+ 1.01675e-06 0
+ 1.017e-06 0
+ 1.0171874999999999e-06 0
+ 1.0172500000000001e-06 0
+ 1.0175e-06 0
+ 1.0177499999999999e-06 0
+ 1.018e-06 0
+ 1.0182499999999999e-06 0
+ 1.0185000000000001e-06 0
+ 1.01875e-06 0
+ 1.0189999999999999e-06 0
+ 1.01925e-06 0
+ 1.0194999999999999e-06 0
+ 1.0197500000000001e-06 0
+ 1.02e-06 0
+ 1.0202500000000001e-06 0
+ 1.0203125e-06 0
+ 1.0205e-06 0
+ 1.0207499999999999e-06 0
+ 1.0210000000000001e-06 0
+ 1.02125e-06 0
+ 1.0215000000000001e-06 0
+ 1.02175e-06 0
+ 1.0218750000000001e-06 0
+ 1.0219999999999999e-06 0
+ 1.02225e-06 0
+ 1.0225e-06 0
+ 1.0227500000000001e-06 0
+ 1.023e-06 0
+ 1.0232499999999999e-06 0
+ 1.0234375000000001e-06 0
+ 1.0235e-06 0
+ 1.0237499999999999e-06 0
+ 1.0240000000000001e-06 0
+ 1.02425e-06 0
+ 1.0245000000000001e-06 0
+ 1.02475e-06 0
+ 1.0249999999999999e-06 0
+ 1.0252500000000001e-06 0
+ 1.0255e-06 0
+ 1.0257500000000001e-06 0
+ 1.026e-06 0
+ 1.0262499999999999e-06 0
+ 1.0265e-06 0
+ 1.0265625e-06 0
+ 1.02675e-06 0
+ 1.0270000000000001e-06 0
+ 1.02725e-06 0
+ 1.0274999999999999e-06 0
+ 1.02775e-06 0
+ 1.0279999999999999e-06 0
+ 1.028125e-06 0
+ 1.0282500000000001e-06 0
+ 1.0285e-06 0
+ 1.0287500000000001e-06 0
+ 1.029e-06 0
+ 1.0292499999999999e-06 0
+ 1.0295000000000001e-06 0
+ 1.0296875e-06 0
+ 1.02975e-06 0
+ 1.0300000000000001e-06 0
+ 1.03025e-06 0
+ 1.0304999999999999e-06 0
+ 1.03075e-06 0
+ 1.031e-06 0
+ 1.0312500000000001e-06 0
+ 1.0315e-06 0
+ 1.0317499999999999e-06 0
+ 1.032e-06 0
+ 1.0322499999999999e-06 0
+ 1.0325000000000001e-06 0
+ 1.03275e-06 0
+ 1.0328124999999999e-06 0
+ 1.0330000000000001e-06 0
+ 1.03325e-06 0
+ 1.0334999999999999e-06 0
+ 1.0337500000000001e-06 0
+ 1.034e-06 0
+ 1.0342500000000001e-06 0
+ 1.0343749999999999e-06 0
+ 1.0345e-06 0
+ 1.0347499999999999e-06 0
+ 1.035e-06 0
+ 1.03525e-06 0
+ 1.0355000000000001e-06 0
+ 1.03575e-06 0
+ 1.0359375e-06 0
+ 1.0359999999999999e-06 0
+ 1.03625e-06 0
+ 1.0364999999999999e-06 0
+ 1.0367500000000001e-06 0
+ 1.037e-06 0
+ 1.0372499999999999e-06 0
+ 1.0375e-06 0
+ 1.0377499999999999e-06 0
+ 1.0380000000000001e-06 0
+ 1.03825e-06 0
+ 1.0385000000000001e-06 0
+ 1.03875e-06 0
+ 1.0389999999999999e-06 0
+ 1.0390625000000001e-06 0
+ 1.03925e-06 0
+ 1.0395e-06 0
+ 1.0397500000000001e-06 0
+ 1.04e-06 0
+ 1.0402499999999999e-06 0
+ 1.0405e-06 0
+ 1.0406250000000001e-06 0
+ 1.0407499999999999e-06 0
+ 1.0410000000000001e-06 0
+ 1.04125e-06 0
+ 1.0414999999999999e-06 0
+ 1.04175e-06 0
+ 1.0419999999999999e-06 0
+ 1.0421874999999999e-06 0
+ 1.0422500000000001e-06 0
+ 1.0425e-06 0
+ 1.0427500000000001e-06 0
+ 1.043e-06 0
+ 1.0432499999999999e-06 0
+ 1.0435e-06 0
+ 1.04375e-06 0
+ 1.0440000000000001e-06 0
+ 1.04425e-06 0
+ 1.0444999999999999e-06 0
+ 1.04475e-06 0
+ 1.0449999999999999e-06 0
+ 1.0452500000000001e-06 0
+ 1.0453125e-06 0
+ 1.0455e-06 0
+ 1.0457499999999999e-06 0
+ 1.046e-06 0
+ 1.0462499999999999e-06 0
+ 1.0465000000000001e-06 0
+ 1.04675e-06 0
+ 1.046875e-06 0
+ 1.0470000000000001e-06 0
+ 1.04725e-06 0
+ 1.0474999999999999e-06 0
+ 1.04775e-06 0
+ 1.048e-06 0
+ 1.0482500000000001e-06 0
+ 1.0484375000000001e-06 0
+ 1.0485e-06 0
+ 1.0487499999999999e-06 0
+ 1.049e-06 0
+ 1.0492499999999999e-06 0
+ 1.0495000000000001e-06 0
+ 1.04975e-06 0
+ 1.0499999999999999e-06 0
+ 1.05025e-06 0
+ 1.0504999999999999e-06 0
+ 1.0507500000000001e-06 0
+ 1.051e-06 0
+ 1.0512500000000001e-06 0
+ 1.0515e-06 0
+ 1.0515624999999999e-06 0
+ 1.0517499999999999e-06 0
+ 1.052e-06 0
+ 1.05225e-06 0
+ 1.0525000000000001e-06 0
+ 1.05275e-06 0
+ 1.0529999999999999e-06 0
+ 1.053125e-06 0
+ 1.05325e-06 0
+ 1.0535e-06 0
+ 1.0537500000000001e-06 0
+ 1.054e-06 0
+ 1.0542499999999999e-06 0
+ 1.0545e-06 0
+ 1.0546875e-06 0
+ 1.0547499999999999e-06 0
+ 1.0550000000000001e-06 0
+ 1.05525e-06 0
+ 1.0555000000000001e-06 0
+ 1.05575e-06 0
+ 1.0559999999999999e-06 0
+ 1.0562500000000001e-06 0
+ 1.0565e-06 0
+ 1.0567500000000001e-06 0
+ 1.057e-06 0
+ 1.0572499999999999e-06 0
+ 1.0575e-06 0
+ 1.05775e-06 0
+ 1.0578125000000001e-06 0
+ 1.0580000000000001e-06 0
+ 1.05825e-06 0
+ 1.0584999999999999e-06 0
+ 1.05875e-06 0
+ 1.0589999999999999e-06 0
+ 1.0592500000000001e-06 0
+ 1.0593749999999999e-06 0
+ 1.0595e-06 0
+ 1.0597500000000001e-06 0
+ 1.06e-06 0
+ 1.0602499999999999e-06 0
+ 1.0605000000000001e-06 0
+ 1.06075e-06 0
+ 1.0609375e-06 0
+ 1.0610000000000001e-06 0
+ 1.06125e-06 0
+ 1.0614999999999999e-06 0
+ 1.06175e-06 0
+ 1.062e-06 0
+ 1.0622500000000001e-06 0
+ 1.0625e-06 0
+ 1.0627499999999999e-06 0
+ 1.063e-06 0
+ 1.0632499999999999e-06 0
+ 1.0635000000000001e-06 0
+ 1.06375e-06 0
+ 1.0640000000000001e-06 0
+ 1.0640625e-06 0
+ 1.06425e-06 0
+ 1.0644999999999999e-06 0
+ 1.0647500000000001e-06 0
+ 1.065e-06 0
+ 1.0652500000000001e-06 0
+ 1.0655e-06 0
+ 1.0656250000000001e-06 0
+ 1.0657499999999999e-06 0
+ 1.066e-06 0
+ 1.06625e-06 0
+ 1.0665000000000001e-06 0
+ 1.06675e-06 0
+ 1.0669999999999999e-06 0
+ 1.0671875000000001e-06 0
+ 1.06725e-06 0
+ 1.0674999999999999e-06 0
+ 1.0677500000000001e-06 0
+ 1.068e-06 0
+ 1.0682499999999999e-06 0
+ 1.0685e-06 0
+ 1.0687499999999999e-06 0
+ 1.0690000000000001e-06 0
+ 1.06925e-06 0
+ 1.0695000000000001e-06 0
+ 1.06975e-06 0
+ 1.0699999999999999e-06 0
+ 1.07025e-06 0
+ 1.0703125e-06 0
+ 1.0705e-06 0
+ 1.0707500000000001e-06 0
+ 1.071e-06 0
+ 1.0712499999999999e-06 0
+ 1.0715e-06 0
+ 1.0717499999999999e-06 0
+ 1.071875e-06 0
+ 1.0720000000000001e-06 0
+ 1.07225e-06 0
+ 1.0724999999999999e-06 0
+ 1.07275e-06 0
+ 1.0729999999999999e-06 0
+ 1.0732500000000001e-06 0
+ 1.0734375e-06 0
+ 1.0735e-06 0
+ 1.0737500000000001e-06 0
+ 1.074e-06 0
+ 1.0742499999999999e-06 0
+ 1.0745e-06 0
+ 1.07475e-06 0
+ 1.0750000000000001e-06 0
+ 1.07525e-06 0
+ 1.0754999999999999e-06 0
+ 1.07575e-06 0
+ 1.0759999999999999e-06 0
+ 1.0762500000000001e-06 0
+ 1.0765e-06 0
+ 1.0765624999999999e-06 0
+ 1.0767499999999999e-06 0
+ 1.077e-06 0
+ 1.0772499999999999e-06 0
+ 1.0775000000000001e-06 0
+ 1.07775e-06 0
+ 1.0780000000000001e-06 0
+ 1.0781249999999999e-06 0
+ 1.07825e-06 0
+ 1.0784999999999999e-06 0
+ 1.07875e-06 0
+ 1.079e-06 0
+ 1.0792500000000001e-06 0
+ 1.0795e-06 0
+ 1.0796875e-06 0
+ 1.0797499999999999e-06 0
+ 1.08e-06 0
+ 1.0802499999999999e-06 0
+ 1.0805000000000001e-06 0
+ 1.08075e-06 0
+ 1.0809999999999999e-06 0
+ 1.08125e-06 0
+ 1.0814999999999999e-06 0
+ 1.0817500000000001e-06 0
+ 1.082e-06 0
+ 1.0822500000000001e-06 0
+ 1.0825e-06 0
+ 1.0827499999999999e-06 0
+ 1.0828125000000001e-06 0
+ 1.083e-06 0
+ 1.08325e-06 0
+ 1.0835000000000001e-06 0
+ 1.08375e-06 0
+ 1.0839999999999999e-06 0
+ 1.08425e-06 0
+ 1.0843750000000001e-06 0
+ 1.0845e-06 0
+ 1.0847500000000001e-06 0
+ 1.085e-06 0
+ 1.0852499999999999e-06 0
+ 1.0855e-06 0
+ 1.0857499999999999e-06 0
+ 1.0859374999999999e-06 0
+ 1.0860000000000001e-06 0
+ 1.08625e-06 0
+ 1.0865000000000001e-06 0
+ 1.08675e-06 0
+ 1.0869999999999999e-06 0
+ 1.0872500000000001e-06 0
+ 1.0875e-06 0
+ 1.0877500000000001e-06 0
+ 1.088e-06 0
+ 1.0882499999999999e-06 0
+ 1.0885e-06 0
+ 1.08875e-06 0
+ 1.0890000000000001e-06 0
+ 1.0890625e-06 0
+ 1.08925e-06 0
+ 1.0894999999999999e-06 0
+ 1.08975e-06 0
+ 1.0899999999999999e-06 0
+ 1.0902500000000001e-06 0
+ 1.0905e-06 0
+ 1.090625e-06 0
+ 1.0907500000000001e-06 0
+ 1.091e-06 0
+ 1.0912499999999999e-06 0
+ 1.0915000000000001e-06 0
+ 1.09175e-06 0
+ 1.0920000000000001e-06 0
+ 1.0921875000000001e-06 0
+ 1.09225e-06 0
+ 1.0924999999999999e-06 0
+ 1.09275e-06 0
+ 1.093e-06 0
+ 1.0932500000000001e-06 0
+ 1.0935e-06 0
+ 1.0937499999999999e-06 0
+ 1.094e-06 0
+ 1.0942499999999999e-06 0
+ 1.0945000000000001e-06 0
+ 1.09475e-06 0
+ 1.0950000000000001e-06 0
+ 1.09525e-06 0
+ 1.0954999999999999e-06 0
+ 1.0957500000000001e-06 0
+ 1.096e-06 0
+ 1.0962500000000001e-06 0
+ 1.0965e-06 0
+ 1.0967499999999999e-06 0
+ 1.097e-06 0
+ 1.09725e-06 0
+ 1.0975000000000001e-06 0
+ 1.09775e-06 0
+ 1.0979999999999999e-06 0
+ 1.09825e-06 0
+ 1.0984999999999999e-06 0
+ 1.0987500000000001e-06 0
+ 1.099e-06 0
+ 1.0992500000000001e-06 0
+ 1.0995e-06 0
+ 1.0997499999999999e-06 0
+ 1.1000000000000001e-06 0
+ 1.10025e-06 0
+ 1.1005000000000001e-06 0
+ 1.10075e-06 0
+ 1.1009999999999999e-06 0
+ 1.10125e-06 0
+ 1.1015e-06 0
+ 1.1017500000000001e-06 0
+ 1.102e-06 0
+ 1.1022499999999999e-06 0
+ 1.1025e-06 0
+ 1.1027499999999999e-06 0
+ 1.1030000000000001e-06 0
+ 1.10325e-06 0
+ 1.1034999999999999e-06 0
+ 1.10375e-06 0
+ 1.1039999999999999e-06 0
+ 1.1042500000000001e-06 0
+ 1.1045e-06 0
+ 1.1047500000000001e-06 0
+ 1.105e-06 0
+ 1.1052499999999999e-06 0
+ 1.1055e-06 0
+ 1.10575e-06 0
+ 1.1060000000000001e-06 0
+ 1.10625e-06 0
+ 1.1064999999999999e-06 0
+ 1.10675e-06 0
+ 1.1069999999999999e-06 0
+ 1.1072500000000001e-06 0
+ 1.1075e-06 0
+ 1.1077499999999999e-06 0
+ 1.108e-06 0
+ 1.1082499999999999e-06 0
+ 1.1085000000000001e-06 0
+ 1.10875e-06 0
+ 1.1090000000000001e-06 0
+ 1.10925e-06 0
+ 1.1094999999999999e-06 0
+ 1.10975e-06 0
+ 1.11e-06 0
+ 1.1102500000000001e-06 0
+ 1.1105e-06 0
+ 1.1107499999999999e-06 0
+ 1.111e-06 0
+ 1.1112499999999999e-06 0
+ 1.1115000000000001e-06 0
+ 1.11175e-06 0
+ 1.1119999999999999e-06 0
+ 1.11225e-06 0
+ 1.1124999999999999e-06 0
+ 1.1127500000000001e-06 0
+ 1.113e-06 0
+ 1.1132500000000001e-06 0
+ 1.1135e-06 0
+ 1.1137499999999999e-06 0
+ 1.114e-06 0
+ 1.11425e-06 0
+ 1.1145000000000001e-06 0
+ 1.11475e-06 0
+ 1.1149999999999999e-06 0
+ 1.11525e-06 0
+ 1.1155e-06 0
+ 1.1157500000000001e-06 0
+ 1.116e-06 0
+ 1.1162499999999999e-06 0
+ 1.1165e-06 0
+ 1.1167499999999999e-06 0
+ 1.1170000000000001e-06 0
+ 1.11725e-06 0
+ 1.1175000000000001e-06 0
+ 1.11775e-06 0
+ 1.1179999999999999e-06 0
+ 1.1182500000000001e-06 0
+ 1.1185e-06 0
+ 1.1187500000000001e-06 0
+ 1.119e-06 0
+ 1.1192499999999999e-06 0
+ 1.1195e-06 0
+ 1.11975e-06 0
+ 1.1200000000000001e-06 0
+ 1.12025e-06 0
+ 1.1204999999999999e-06 0
+ 1.12075e-06 0
+ 1.1209999999999999e-06 0
+ 1.1212500000000001e-06 0
+ 1.1215e-06 0
+ 1.1217500000000001e-06 0
+ 1.122e-06 0
+ 1.1222499999999999e-06 0
+ 1.1225000000000001e-06 0
+ 1.12275e-06 0
+ 1.1230000000000001e-06 0
+ 1.12325e-06 0
+ 1.1234999999999999e-06 0
+ 1.12375e-06 0
+ 1.124e-06 0
+ 1.1242500000000001e-06 0
+ 1.1245e-06 0
+ 1.1247499999999999e-06 0
+ 1.125e-06 0
+ 1.1252499999999999e-06 0
+ 1.1255000000000001e-06 0
+ 1.12575e-06 0
+ 1.1260000000000001e-06 0
+ 1.12625e-06 0
+ 1.1264999999999999e-06 0
+ 1.1267500000000001e-06 0
+ 1.127e-06 0
+ 1.1272500000000001e-06 0
+ 1.1275e-06 0
+ 1.1277499999999999e-06 0
+ 1.128e-06 0
+ 1.12825e-06 0
+ 1.1285000000000001e-06 0
+ 1.12875e-06 0
+ 1.1289999999999999e-06 0
+ 1.12925e-06 0
+ 1.1294999999999999e-06 0
+ 1.1297500000000001e-06 0
+ 1.13e-06 0
+ 1.1302500000000001e-06 0
+ 1.1305e-06 0
+ 1.1307499999999999e-06 0
+ 1.1310000000000001e-06 0
+ 1.13125e-06 0
+ 1.1315000000000001e-06 0
+ 1.13175e-06 0
+ 1.1319999999999999e-06 0
+ 1.13225e-06 0
+ 1.1325e-06 0
+ 1.1327500000000001e-06 0
+ 1.133e-06 0
+ 1.1332499999999999e-06 0
+ 1.1335e-06 0
+ 1.1337499999999999e-06 0
+ 1.1340000000000001e-06 0
+ 1.13425e-06 0
+ 1.1344999999999999e-06 0
+ 1.13475e-06 0
+ 1.1349999999999999e-06 0
+ 1.1352500000000001e-06 0
+ 1.1355e-06 0
+ 1.1357500000000001e-06 0
+ 1.136e-06 0
+ 1.1362499999999999e-06 0
+ 1.1365e-06 0
+ 1.13675e-06 0
+ 1.1370000000000001e-06 0
+ 1.13725e-06 0
+ 1.1374999999999999e-06 0
+ 1.13775e-06 0
+ 1.1379999999999999e-06 0
+ 1.1382500000000001e-06 0
+ 1.1385e-06 0
+ 1.1387499999999999e-06 0
+ 1.139e-06 0
+ 1.1392499999999999e-06 0
+ 1.1395000000000001e-06 0
+ 1.13975e-06 0
+ 1.1400000000000001e-06 0
+ 1.14025e-06 0
+ 1.1404999999999999e-06 0
+ 1.14075e-06 0
+ 1.141e-06 0
+ 1.1412500000000001e-06 0
+ 1.1415e-06 0
+ 1.1417499999999999e-06 0
+ 1.142e-06 0
+ 1.1422499999999999e-06 0
+ 1.1425000000000001e-06 0
+ 1.14275e-06 0
+ 1.1429999999999999e-06 0
+ 1.14325e-06 0
+ 1.1434999999999999e-06 0
+ 1.1437500000000001e-06 0
+ 1.144e-06 0
+ 1.1442500000000001e-06 0
+ 1.1445e-06 0
+ 1.1447499999999999e-06 0
+ 1.145e-06 0
+ 1.14525e-06 0
+ 1.1455000000000001e-06 0
+ 1.14575e-06 0
+ 1.1459999999999999e-06 0
+ 1.14625e-06 0
+ 1.1464999999999999e-06 0
+ 1.1467500000000001e-06 0
+ 1.147e-06 0
+ 1.1472499999999999e-06 0
+ 1.1475e-06 0
+ 1.1477499999999999e-06 0
+ 1.1480000000000001e-06 0
+ 1.14825e-06 0
+ 1.1485000000000001e-06 0
+ 1.14875e-06 0
+ 1.1489999999999999e-06 0
+ 1.1492500000000001e-06 0
+ 1.1495e-06 0
+ 1.1497500000000001e-06 0
+ 1.15e-06 0
+ 1.1502499999999999e-06 0
+ 1.1505e-06 0
+ 1.15075e-06 0
+ 1.1510000000000001e-06 0
+ 1.15125e-06 0
+ 1.1514999999999999e-06 0
+ 1.15175e-06 0
+ 1.1519999999999999e-06 0
+ 1.1522500000000001e-06 0
+ 1.1525e-06 0
+ 1.1527500000000001e-06 0
+ 1.153e-06 0
+ 1.1532499999999999e-06 0
+ 1.1535000000000001e-06 0
+ 1.15375e-06 0
+ 1.1540000000000001e-06 0
+ 1.15425e-06 0
+ 1.1544999999999999e-06 0
+ 1.15475e-06 0
+ 1.155e-06 0
+ 1.1552500000000001e-06 0
+ 1.1555e-06 0
+ 1.1557499999999999e-06 0
+ 1.156e-06 0
+ 1.1562499999999999e-06 0
+ 1.1565000000000001e-06 0
+ 1.15675e-06 0
+ 1.1570000000000001e-06 0
+ 1.15725e-06 0
+ 1.1574999999999999e-06 0
+ 1.1577500000000001e-06 0
+ 1.158e-06 0
+ 1.1582500000000001e-06 0
+ 1.1585e-06 0
+ 1.1587499999999999e-06 0
+ 1.159e-06 0
+ 1.15925e-06 0
+ 1.1595000000000001e-06 0
+ 1.15975e-06 0
+ 1.1599999999999999e-06 0
+ 1.16025e-06 0
+ 1.1604999999999999e-06 0
+ 1.1607500000000001e-06 0
+ 1.161e-06 0
+ 1.1612500000000001e-06 0
+ 1.1615e-06 0
+ 1.1617499999999999e-06 0
+ 1.1620000000000001e-06 0
+ 1.16225e-06 0
+ 1.1625000000000001e-06 0
+ 1.16275e-06 0
+ 1.1629999999999999e-06 0
+ 1.16325e-06 0
+ 1.1635e-06 0
+ 1.1637500000000001e-06 0
+ 1.164e-06 0
+ 1.1642499999999999e-06 0
+ 1.1645e-06 0
+ 1.1647499999999999e-06 0
+ 1.1650000000000001e-06 0
+ 1.16525e-06 0
+ 1.1654999999999999e-06 0
+ 1.16575e-06 0
+ 1.1659999999999999e-06 0
+ 1.1662500000000001e-06 0
+ 1.1665e-06 0
+ 1.1667500000000001e-06 0
+ 1.167e-06 0
+ 1.1672499999999999e-06 0
+ 1.1675e-06 0
+ 1.16775e-06 0
+ 1.1680000000000001e-06 0
+ 1.16825e-06 0
+ 1.1684999999999999e-06 0
+ 1.16875e-06 0
+ 1.1689999999999999e-06 0
+ 1.1692500000000001e-06 0
+ 1.1695e-06 0
+ 1.1697499999999999e-06 0
+ 1.17e-06 0
+ 1.1702499999999999e-06 0
+ 1.1705000000000001e-06 0
+ 1.17075e-06 0
+ 1.1710000000000001e-06 0
+ 1.17125e-06 0
+ 1.1714999999999999e-06 0
+ 1.17175e-06 0
+ 1.172e-06 0
+ 1.1722500000000001e-06 0
+ 1.1725e-06 0
+ 1.1727499999999999e-06 0
+ 1.173e-06 0
+ 1.1732499999999999e-06 0
+ 1.1735000000000001e-06 0
+ 1.17375e-06 0
+ 1.1739999999999999e-06 0
+ 1.17425e-06 0
+ 1.1744999999999999e-06 0
+ 1.1747500000000001e-06 0
+ 1.175e-06 0
+ 1.1752500000000001e-06 0
+ 1.1755e-06 0
+ 1.1757499999999999e-06 0
+ 1.176e-06 0
+ 1.17625e-06 0
+ 1.1765000000000001e-06 0
+ 1.17675e-06 0
+ 1.1769999999999999e-06 0
+ 1.17725e-06 0
+ 1.1774999999999999e-06 0
+ 1.1777500000000001e-06 0
+ 1.178e-06 0
+ 1.1782499999999999e-06 0
+ 1.1785e-06 0
+ 1.1787499999999999e-06 0
+ 1.1790000000000001e-06 0
+ 1.17925e-06 0
+ 1.1795000000000001e-06 0
+ 1.17975e-06 0
+ 1.1799999999999999e-06 0
+ 1.1802500000000001e-06 0
+ 1.1805e-06 0
+ 1.1807500000000001e-06 0
+ 1.181e-06 0
+ 1.1812499999999999e-06 0
+ 1.1815e-06 0
+ 1.18175e-06 0
+ 1.1820000000000001e-06 0
+ 1.18225e-06 0
+ 1.1824999999999999e-06 0
+ 1.18275e-06 0
+ 1.1829999999999999e-06 0
+ 1.1832500000000001e-06 0
+ 1.1835e-06 0
+ 1.1837500000000001e-06 0
+ 1.184e-06 0
+ 1.1842499999999999e-06 0
+ 1.1845000000000001e-06 0
+ 1.18475e-06 0
+ 1.1850000000000001e-06 0
+ 1.18525e-06 0
+ 1.1854999999999999e-06 0
+ 1.18575e-06 0
+ 1.186e-06 0
+ 1.1862500000000001e-06 0
+ 1.1865e-06 0
+ 1.1867499999999999e-06 0
+ 1.187e-06 0
+ 1.1872499999999999e-06 0
+ 1.1875000000000001e-06 0
+ 1.18775e-06 0
+ 1.1880000000000001e-06 0
+ 1.18825e-06 0
+ 1.1884999999999999e-06 0
+ 1.1887500000000001e-06 0
+ 1.189e-06 0
+ 1.1892500000000001e-06 0
+ 1.1895e-06 0
+ 1.1897499999999999e-06 0
+ 1.19e-06 0
+ 1.19025e-06 0
+ 1.1905000000000001e-06 0
+ 1.19075e-06 0
+ 1.1909999999999999e-06 0
+ 1.19125e-06 0
+ 1.1914999999999999e-06 0
+ 1.1917500000000001e-06 0
+ 1.192e-06 0
+ 1.1922500000000001e-06 0
+ 1.1925e-06 0
+ 1.1927499999999999e-06 0
+ 1.1930000000000001e-06 0
+ 1.19325e-06 0
+ 1.1935000000000001e-06 0
+ 1.19375e-06 0
+ 1.1939999999999999e-06 0
+ 1.19425e-06 0
+ 1.1945e-06 0
+ 1.1947500000000001e-06 0
+ 1.195e-06 0
+ 1.1952499999999999e-06 0
+ 1.1955e-06 0
+ 1.1957499999999999e-06 0
+ 1.1960000000000001e-06 0
+ 1.19625e-06 0
+ 1.1964999999999999e-06 0
+ 1.19675e-06 0
+ 1.1969999999999999e-06 0
+ 1.1972500000000001e-06 0
+ 1.1975e-06 0
+ 1.1977500000000001e-06 0
+ 1.198e-06 0
+ 1.1982499999999999e-06 0
+ 1.1985e-06 0
+ 1.19875e-06 0
+ 1.1990000000000001e-06 0
+ 1.19925e-06 0
+ 1.1994999999999999e-06 0
+ 1.19975e-06 0
+ 1.1999999999999999e-06 0
+ 1.2002500000000001e-06 0
+ 1.2005e-06 0
+ 1.2007499999999999e-06 0
+ 1.201e-06 0
+ 1.2012499999999999e-06 0
+ 1.2015000000000001e-06 0
+ 1.20175e-06 0
+ 1.2020000000000001e-06 0
+ 1.20225e-06 0
+ 1.2024999999999999e-06 0
+ 1.20275e-06 0
+ 1.203e-06 0
+ 1.2032500000000001e-06 0
+ 1.2035e-06 0
+ 1.2037499999999999e-06 0
+ 1.204e-06 0
+ 1.2042499999999999e-06 0
+ 1.2045000000000001e-06 0
+ 1.20475e-06 0
+ 1.2049999999999999e-06 0
+ 1.20525e-06 0
+ 1.2054999999999999e-06 0
+ 1.2057500000000001e-06 0
+ 1.206e-06 0
+ 1.2062500000000001e-06 0
+ 1.206278e-06 0
+ 1.2065e-06 0
+ 1.2067499999999999e-06 0
+ 1.207e-06 0
+ 1.20725e-06 0
+ 1.2075000000000001e-06 0
+ 1.20775e-06 0
+ 1.2079999999999999e-06 0
+ 1.20825e-06 0
+ 1.2084999999999999e-06 0
+ 1.2087500000000001e-06 0
+ 1.209e-06 0
+ 1.2092499999999999e-06 0
+ 1.2095e-06 0
+ 1.2097499999999999e-06 0
+ 1.2100000000000001e-06 0
+ 1.21025e-06 0
+ 1.2105000000000001e-06 0
+ 1.21075e-06 0
+ 1.2109999999999999e-06 0
+ 1.21125e-06 0
+ 1.2115e-06 0
+ 1.2117500000000001e-06 0
+ 1.212e-06 0
+ 1.2122499999999999e-06 0
+ 1.2125e-06 0
+ 1.21275e-06 0
+ 1.2130000000000001e-06 0
+ 1.21325e-06 0
+ 1.2134999999999999e-06 0
+ 1.21375e-06 0
+ 1.2139999999999999e-06 0
+ 1.2142500000000001e-06 0
+ 1.2145e-06 0
+ 1.2147500000000001e-06 0
+ 1.215e-06 0
+ 1.2152499999999999e-06 0
+ 1.2155000000000001e-06 0
+ 1.21575e-06 0
+ 1.2160000000000001e-06 0
+ 1.21625e-06 0
+ 1.2164999999999999e-06 0
+ 1.21675e-06 0
+ 1.217e-06 0
+ 1.2172500000000001e-06 0
+ 1.2175e-06 0
+ 1.2177499999999999e-06 0
+ 1.218e-06 0
+ 1.2182499999999999e-06 0
+ 1.2185000000000001e-06 0
+ 1.21875e-06 0
+ 1.2190000000000001e-06 0
+ 1.21925e-06 0
+ 1.2194999999999999e-06 0
+ 1.2197500000000001e-06 0
+ 1.22e-06 0
+ 1.2202500000000001e-06 0
+ 1.2205e-06 0
+ 1.2207499999999999e-06 0
+ 1.221e-06 0
+ 1.22125e-06 0
+ 1.2215000000000001e-06 0
+ 1.22175e-06 0
+ 1.2219999999999999e-06 0
+ 1.22225e-06 0
+ 1.2224999999999999e-06 0
+ 1.2227500000000001e-06 0
+ 1.223e-06 0
+ 1.2232500000000001e-06 0
+ 1.2235e-06 0
+ 1.2237499999999999e-06 0
+ 1.2240000000000001e-06 0
+ 1.22425e-06 0
+ 1.2245000000000001e-06 0
+ 1.22475e-06 0
+ 1.2249999999999999e-06 0
+ 1.22525e-06 0
+ 1.2255e-06 0
+ 1.2257500000000001e-06 0
+ 1.226e-06 0
+ 1.2262499999999999e-06 0
+ 1.2265e-06 0
+ 1.2267499999999999e-06 0
+ 1.2270000000000001e-06 0
+ 1.22725e-06 0
+ 1.2274999999999999e-06 0
+ 1.22775e-06 0
+ 1.2279999999999999e-06 0
+ 1.2282500000000001e-06 0
+ 1.2285e-06 0
+ 1.2287500000000001e-06 0
+ 1.229e-06 0
+ 1.2292499999999999e-06 0
+ 1.2295e-06 0
+ 1.22975e-06 0
+ 1.2300000000000001e-06 0
+ 1.23025e-06 0
+ 1.2304999999999999e-06 0
+ 1.23075e-06 0
+ 1.2309999999999999e-06 0
+ 1.2312500000000001e-06 0
+ 1.2315e-06 0
+ 1.2317499999999999e-06 0
+ 1.232e-06 0
+ 1.2322499999999999e-06 0
+ 1.2325000000000001e-06 0
+ 1.23275e-06 0
+ 1.2330000000000001e-06 0
+ 1.23325e-06 0
+ 1.2334999999999999e-06 0
+ 1.23375e-06 0
+ 1.234e-06 0
+ 1.2342500000000001e-06 0
+ 1.2345e-06 0
+ 1.2347499999999999e-06 0
+ 1.235e-06 0
+ 1.2352499999999999e-06 0
+ 1.2355000000000001e-06 0
+ 1.23575e-06 0
+ 1.2359999999999999e-06 0
+ 1.23625e-06 0
+ 1.2364999999999999e-06 0
+ 1.2367500000000001e-06 0
+ 1.237e-06 0
+ 1.2372500000000001e-06 0
+ 1.2375e-06 0
+ 1.2377499999999999e-06 0
+ 1.238e-06 0
+ 1.23825e-06 0
+ 1.2385000000000001e-06 0
+ 1.23875e-06 0
+ 1.2389999999999999e-06 0
+ 1.23925e-06 0
+ 1.2394999999999999e-06 0
+ 1.2397500000000001e-06 0
+ 1.24e-06 0
+ 1.2402499999999999e-06 0
+ 1.2405e-06 0
+ 1.2407499999999999e-06 0
+ 1.2410000000000001e-06 0
+ 1.24125e-06 0
+ 1.2415000000000001e-06 0
+ 1.24175e-06 0
+ 1.2419999999999999e-06 0
+ 1.24225e-06 0
+ 1.2425e-06 0
+ 1.2427500000000001e-06 0
+ 1.243e-06 0
+ 1.2432499999999999e-06 0
+ 1.2435e-06 0
+ 1.24375e-06 0
+ 1.2440000000000001e-06 0
+ 1.24425e-06 0
+ 1.2444999999999999e-06 0
+ 1.24475e-06 0
+ 1.2449999999999999e-06 0
+ 1.2452500000000001e-06 0
+ 1.2455e-06 0
+ 1.2457500000000001e-06 0
+ 1.246e-06 0
+ 1.2462499999999999e-06 0
+ 1.2465000000000001e-06 0
+ 1.24675e-06 0
+ 1.2470000000000001e-06 0
+ 1.24725e-06 0
+ 1.2474999999999999e-06 0
+ 1.24775e-06 0
+ 1.248e-06 0
+ 1.2482500000000001e-06 0
+ 1.2485e-06 0
+ 1.2487499999999999e-06 0
+ 1.249e-06 0
+ 1.2492499999999999e-06 0
+ 1.2495000000000001e-06 0
+ 1.24975e-06 0
+ 1.2500000000000001e-06 0
+ 1.25025e-06 0
+ 1.2504999999999999e-06 0
+ 1.2507500000000001e-06 0
+ 1.251e-06 0
+ 1.2512500000000001e-06 0
+ 1.2515e-06 0
+ 1.2517499999999999e-06 0
+ 1.252e-06 0
+ 1.25225e-06 0
+ 1.2525000000000001e-06 0
+ 1.25275e-06 0
+ 1.2529999999999999e-06 0
+ 1.25325e-06 0
+ 1.2534999999999999e-06 0
+ 1.2537500000000001e-06 0
+ 1.254e-06 0
+ 1.2542500000000001e-06 0
+ 1.2545e-06 0
+ 1.2547499999999999e-06 0
+ 1.2550000000000001e-06 0
+ 1.25525e-06 0
+ 1.2555000000000001e-06 0
+ 1.25575e-06 0
+ 1.2559999999999999e-06 0
+ 1.25625e-06 0
+ 1.2565e-06 0
+ 1.2567500000000001e-06 0
+ 1.257e-06 0
+ 1.2572499999999999e-06 0
+ 1.2575e-06 0
+ 1.2577499999999999e-06 0
+ 1.2580000000000001e-06 0
+ 1.25825e-06 0
+ 1.2585000000000001e-06 0
+ 1.25875e-06 0
+ 1.2589999999999999e-06 0
+ 1.2592500000000001e-06 0
+ 1.2595e-06 0
+ 1.2597500000000001e-06 0
+ 1.26e-06 0
+ 1.2602499999999999e-06 0
+ 1.2605e-06 0
+ 1.26075e-06 0
+ 1.2610000000000001e-06 0
+ 1.26125e-06 0
+ 1.2614999999999999e-06 0
+ 1.26175e-06 0
+ 1.2619999999999999e-06 0
+ 1.2622500000000001e-06 0
+ 1.2625e-06 0
+ 1.2627499999999999e-06 0
+ 1.263e-06 0
+ 1.2632499999999999e-06 0
+ 1.2635000000000001e-06 0
+ 1.26375e-06 0
+ 1.2640000000000001e-06 0
+ 1.26425e-06 0
+ 1.2644999999999999e-06 0
+ 1.26475e-06 0
+ 1.265e-06 0
+ 1.2652500000000001e-06 0
+ 1.2655e-06 0
+ 1.2657499999999999e-06 0
+ 1.266e-06 0
+ 1.2662499999999999e-06 0
+ 1.2665000000000001e-06 0
+ 1.26675e-06 0
+ 1.2669999999999999e-06 0
+ 1.26725e-06 0
+ 1.2674999999999999e-06 0
+ 1.2677500000000001e-06 0
+ 1.268e-06 0
+ 1.2682500000000001e-06 0
+ 1.2685e-06 0
+ 1.2687499999999999e-06 0
+ 1.269e-06 0
+ 1.26925e-06 0
+ 1.2695000000000001e-06 0
+ 1.26975e-06 0
+ 1.2699999999999999e-06 0
+ 1.27025e-06 0
+ 1.2704999999999999e-06 0
+ 1.2707500000000001e-06 0
+ 1.271e-06 0
+ 1.2712499999999999e-06 0
+ 1.2715e-06 0
+ 1.2717499999999999e-06 0
+ 1.2720000000000001e-06 0
+ 1.27225e-06 0
+ 1.2725000000000001e-06 0
+ 1.27275e-06 0
+ 1.2729999999999999e-06 0
+ 1.27325e-06 0
+ 1.2735e-06 0
+ 1.2737500000000001e-06 0
+ 1.274e-06 0
+ 1.2742499999999999e-06 0
+ 1.2745e-06 0
+ 1.2747499999999999e-06 0
+ 1.2750000000000001e-06 0
+ 1.27525e-06 0
+ 1.2754999999999999e-06 0
+ 1.27575e-06 0
+ 1.2759999999999999e-06 0
+ 1.2762500000000001e-06 0
+ 1.2765e-06 0
+ 1.2767500000000001e-06 0
+ 1.277e-06 0
+ 1.2772499999999999e-06 0
+ 1.2775000000000001e-06 0
+ 1.27775e-06 0
+ 1.2780000000000001e-06 0
+ 1.27825e-06 0
+ 1.2784999999999999e-06 0
+ 1.27875e-06 0
+ 1.279e-06 0
+ 1.2792500000000001e-06 0
+ 1.2795e-06 0
+ 1.2797499999999999e-06 0
+ 1.28e-06 0
+ 1.2802499999999999e-06 0
+ 1.2805000000000001e-06 0
+ 1.28075e-06 0
+ 1.2810000000000001e-06 0
+ 1.28125e-06 0
+ 1.2814999999999999e-06 0
+ 1.2817500000000001e-06 0
+ 1.282e-06 0
+ 1.2822500000000001e-06 0
+ 1.2825e-06 0
+ 1.2827499999999999e-06 0
+ 1.283e-06 0
+ 1.28325e-06 0
+ 1.2835000000000001e-06 0
+ 1.28375e-06 0
+ 1.2839999999999999e-06 0
+ 1.28425e-06 0
+ 1.2844999999999999e-06 0
+ 1.2847500000000001e-06 0
+ 1.285e-06 0
+ 1.2852500000000001e-06 0
+ 1.2855e-06 0
+ 1.2857499999999999e-06 0
+ 1.2860000000000001e-06 0
+ 1.28625e-06 0
+ 1.2865000000000001e-06 0
+ 1.28675e-06 0
+ 1.2869999999999999e-06 0
+ 1.28725e-06 0
+ 1.2875e-06 0
+ 1.2877500000000001e-06 0
+ 1.288e-06 0
+ 1.2882499999999999e-06 0
+ 1.2885e-06 0
+ 1.2887499999999999e-06 0
+ 1.2890000000000001e-06 0
+ 1.28925e-06 0
+ 1.2895000000000001e-06 0
+ 1.28975e-06 0
+ 1.2899999999999999e-06 0
+ 1.2902500000000001e-06 0
+ 1.2905e-06 0
+ 1.2907500000000001e-06 0
+ 1.291e-06 0
+ 1.2912499999999999e-06 0
+ 1.2915e-06 0
+ 1.29175e-06 0
+ 1.2920000000000001e-06 0
+ 1.29225e-06 0
+ 1.2924999999999999e-06 0
+ 1.29275e-06 0
+ 1.2929999999999999e-06 0
+ 1.2932500000000001e-06 0
+ 1.2935e-06 0
+ 1.2937499999999999e-06 0
+ 1.294e-06 0
+ 1.2942499999999999e-06 0
+ 1.2945000000000001e-06 0
+ 1.29475e-06 0
+ 1.2950000000000001e-06 0
+ 1.29525e-06 0
+ 1.2954999999999999e-06 0
+ 1.29575e-06 0
+ 1.296e-06 0
+ 1.2962500000000001e-06 0
+ 1.2965e-06 0
+ 1.2967499999999999e-06 0
+ 1.297e-06 0
+ 1.2972499999999999e-06 0
+ 1.2975000000000001e-06 0
+ 1.29775e-06 0
+ 1.2979999999999999e-06 0
+ 1.29825e-06 0
+ 1.2984999999999999e-06 0
+ 1.2987500000000001e-06 0
+ 1.299e-06 0
+ 1.2992500000000001e-06 0
+ 1.2995e-06 0
+ 1.2997499999999999e-06 0
+ 1.3e-06 0
+ 1.30025e-06 0
+ 1.3005000000000001e-06 0
+ 1.30075e-06 0
+ 1.3009999999999999e-06 0
+ 1.30125e-06 0
+ 1.3014999999999999e-06 0
+ 1.3017500000000001e-06 0
+ 1.302e-06 0
+ 1.3022499999999999e-06 0
+ 1.3025e-06 0
+ 1.3027499999999999e-06 0
+ 1.3030000000000001e-06 0
+ 1.30325e-06 0
+ 1.3035000000000001e-06 0
+ 1.30375e-06 0
+ 1.3039999999999999e-06 0
+ 1.30425e-06 0
+ 1.3045e-06 0
+ 1.3047500000000001e-06 0
+ 1.305e-06 0
+ 1.3052499999999999e-06 0
+ 1.3055e-06 0
+ 1.3057499999999999e-06 0
+ 1.3060000000000001e-06 0
+ 1.30625e-06 0
+ 1.3064999999999999e-06 0
+ 1.30675e-06 0
+ 1.3069999999999999e-06 0
+ 1.3072500000000001e-06 0
+ 1.3075e-06 0
+ 1.3077500000000001e-06 0
+ 1.308e-06 0
+ 1.3082499999999999e-06 0
+ 1.3085000000000001e-06 0
+ 1.30875e-06 0
+ 1.3090000000000001e-06 0
+ 1.30925e-06 0
+ 1.3094999999999999e-06 0
+ 1.30975e-06 0
+ 1.31e-06 0
+ 1.3102500000000001e-06 0
+ 1.3105e-06 0
+ 1.3107499999999999e-06 0
+ 1.311e-06 0
+ 1.3112499999999999e-06 0
+ 1.3115000000000001e-06 0
+ 1.31175e-06 0
+ 1.3120000000000001e-06 0
+ 1.31225e-06 0
+ 1.3124999999999999e-06 0
+ 1.3127500000000001e-06 0
+ 1.313e-06 0
+ 1.3132500000000001e-06 0
+ 1.3135e-06 0
+ 1.3137499999999999e-06 0
+ 1.314e-06 0
+ 1.31425e-06 0
+ 1.3145000000000001e-06 0
+ 1.31475e-06 0
+ 1.3149999999999999e-06 0
+ 1.31525e-06 0
+ 1.3154999999999999e-06 0
+ 1.3157500000000001e-06 0
+ 1.316e-06 0
+ 1.3162500000000001e-06 0
+ 1.3165e-06 0
+ 1.3167499999999999e-06 0
+ 1.3170000000000001e-06 0
+ 1.31725e-06 0
+ 1.3175000000000001e-06 0
+ 1.31775e-06 0
+ 1.3179999999999999e-06 0
+ 1.31825e-06 0
+ 1.3185e-06 0
+ 1.3187500000000001e-06 0
+ 1.319e-06 0
+ 1.3192499999999999e-06 0
+ 1.3195e-06 0
+ 1.3197499999999999e-06 0
+ 1.3200000000000001e-06 0
+ 1.32025e-06 0
+ 1.3205000000000001e-06 0
+ 1.32075e-06 0
+ 1.3209999999999999e-06 0
+ 1.3212500000000001e-06 0
+ 1.3215e-06 0
+ 1.3217500000000001e-06 0
+ 1.322e-06 0
+ 1.3222499999999999e-06 0
+ 1.3225e-06 0
+ 1.32275e-06 0
+ 1.3230000000000001e-06 0
+ 1.32325e-06 0
+ 1.3234999999999999e-06 0
+ 1.32375e-06 0
+ 1.3239999999999999e-06 0
+ 1.3242500000000001e-06 0
+ 1.3245e-06 0
+ 1.3247499999999999e-06 0
+ 1.325e-06 0
+ 1.3252499999999999e-06 0
+ 1.3255000000000001e-06 0
+ 1.32575e-06 0
+ 1.3260000000000001e-06 0
+ 1.32625e-06 0
+ 1.3264999999999999e-06 0
+ 1.32675e-06 0
+ 1.327e-06 0
+ 1.3272500000000001e-06 0
+ 1.3275e-06 0
+ 1.3277499999999999e-06 0
+ 1.328e-06 0
+ 1.3282499999999999e-06 0
+ 1.3285000000000001e-06 0
+ 1.32875e-06 0
+ 1.3289999999999999e-06 0
+ 1.32925e-06 0
+ 1.3294999999999999e-06 0
+ 1.3297500000000001e-06 0
+ 1.33e-06 0
+ 1.3302500000000001e-06 0
+ 1.3305e-06 0
+ 1.3307499999999999e-06 0
+ 1.331e-06 0
+ 1.33125e-06 0
+ 1.3315000000000001e-06 0
+ 1.33175e-06 0
+ 1.3319999999999999e-06 0
+ 1.33225e-06 0
+ 1.3324999999999999e-06 0
+ 1.3327500000000001e-06 0
+ 1.333e-06 0
+ 1.3332499999999999e-06 0
+ 1.3335e-06 0
+ 1.3337499999999999e-06 0
+ 1.3340000000000001e-06 0
+ 1.33425e-06 0
+ 1.3345000000000001e-06 0
+ 1.33475e-06 0
+ 1.3349999999999999e-06 0
+ 1.33525e-06 0
+ 1.3355e-06 0
+ 1.3357500000000001e-06 0
+ 1.336e-06 0
+ 1.3362499999999999e-06 0
+ 1.3365e-06 0
+ 1.3367499999999999e-06 0
+ 1.3370000000000001e-06 0
+ 1.33725e-06 0
+ 1.3374999999999999e-06 0
+ 1.33775e-06 0
+ 1.3379999999999999e-06 0
+ 1.3382500000000001e-06 0
+ 1.3385e-06 0
+ 1.3387500000000001e-06 0
+ 1.339e-06 0
+ 1.3392499999999999e-06 0
+ 1.3395000000000001e-06 0
+ 1.33975e-06 0
+ 1.3400000000000001e-06 0
+ 1.34025e-06 0
+ 1.3404999999999999e-06 0
+ 1.34075e-06 0
+ 1.341e-06 0
+ 1.3412500000000001e-06 0
+ 1.3415e-06 0
+ 1.3417499999999999e-06 0
+ 1.342e-06 0
+ 1.3422499999999999e-06 0
+ 1.3425000000000001e-06 0
+ 1.34275e-06 0
+ 1.3430000000000001e-06 0
+ 1.34325e-06 0
+ 1.3434999999999999e-06 0
+ 1.3437500000000001e-06 0
+ 1.344e-06 0
+ 1.3442500000000001e-06 0
+ 1.3445e-06 0
+ 1.3447499999999999e-06 0
+ 1.345e-06 0
+ 1.34525e-06 0
+ 1.3455000000000001e-06 0
+ 1.34575e-06 0
+ 1.3459999999999999e-06 0
+ 1.34625e-06 0
+ 1.3464999999999999e-06 0
+ 1.3467500000000001e-06 0
+ 1.347e-06 0
+ 1.3472500000000001e-06 0
+ 1.3475e-06 0
+ 1.3477499999999999e-06 0
+ 1.3480000000000001e-06 0
+ 1.34825e-06 0
+ 1.3485000000000001e-06 0
+ 1.34875e-06 0
+ 1.3489999999999999e-06 0
+ 1.34925e-06 0
+ 1.3495e-06 0
+ 1.3497500000000001e-06 0
+ 1.35e-06 0
+ 1.3502499999999999e-06 0
+ 1.3505e-06 0
+ 1.3507499999999999e-06 0
+ 1.3510000000000001e-06 0
+ 1.35125e-06 0
+ 1.3515000000000001e-06 0
+ 1.35175e-06 0
+ 1.3519999999999999e-06 0
+ 1.3522500000000001e-06 0
+ 1.3525e-06 0
+ 1.3527500000000001e-06 0
+ 1.353e-06 0
+ 1.3532499999999999e-06 0
+ 1.3535e-06 0
+ 1.35375e-06 0
+ 1.3540000000000001e-06 0
+ 1.35425e-06 0
+ 1.3544999999999999e-06 0
+ 1.35475e-06 0
+ 1.3549999999999999e-06 0
+ 1.3552500000000001e-06 0
+ 1.3555e-06 0
+ 1.3557499999999999e-06 0
+ 1.356e-06 0
+ 1.3562499999999999e-06 0
+ 1.3565000000000001e-06 0
+ 1.35675e-06 0
+ 1.3570000000000001e-06 0
+ 1.35725e-06 0
+ 1.3574999999999999e-06 0
+ 1.35775e-06 0
+ 1.358e-06 0
+ 1.3582500000000001e-06 0
+ 1.3585e-06 0
+ 1.3587499999999999e-06 0
+ 1.359e-06 0
+ 1.3592499999999999e-06 0
+ 1.3595000000000001e-06 0
+ 1.35975e-06 0
+ 1.3599999999999999e-06 0
+ 1.36025e-06 0
+ 1.3604999999999999e-06 0
+ 1.3607500000000001e-06 0
+ 1.361e-06 0
+ 1.3612500000000001e-06 0
+ 1.3615e-06 0
+ 1.3617499999999999e-06 0
+ 1.362e-06 0
+ 1.36225e-06 0
+ 1.3625000000000001e-06 0
+ 1.36275e-06 0
+ 1.3629999999999999e-06 0
+ 1.36325e-06 0
+ 1.3634999999999999e-06 0
+ 1.3637500000000001e-06 0
+ 1.364e-06 0
+ 1.3642499999999999e-06 0
+ 1.3645e-06 0
+ 1.3647499999999999e-06 0
+ 1.3650000000000001e-06 0
+ 1.36525e-06 0
+ 1.3655000000000001e-06 0
+ 1.36575e-06 0
+ 1.3659999999999999e-06 0
+ 1.36625e-06 0
+ 1.3665e-06 0
+ 1.3667500000000001e-06 0
+ 1.367e-06 0
+ 1.3672499999999999e-06 0
+ 1.3675e-06 0
+ 1.3677499999999999e-06 0
+ 1.3680000000000001e-06 0
+ 1.36825e-06 0
+ 1.3684999999999999e-06 0
+ 1.36875e-06 0
+ 1.3689999999999999e-06 0
+ 1.3692500000000001e-06 0
+ 1.3695e-06 0
+ 1.3697500000000001e-06 0
+ 1.37e-06 0
+ 1.3702499999999999e-06 0
+ 1.3705e-06 0
+ 1.37075e-06 0
+ 1.3710000000000001e-06 0
+ 1.37125e-06 0
+ 1.3714999999999999e-06 0
+ 1.37175e-06 0
+ 1.372e-06 0
+ 1.3722500000000001e-06 0
+ 1.3725e-06 0
+ 1.3727499999999999e-06 0
+ 1.373e-06 0
+ 1.3732499999999999e-06 0
+ 1.3735000000000001e-06 0
+ 1.37375e-06 0
+ 1.3740000000000001e-06 0
+ 1.37425e-06 0
+ 1.3744999999999999e-06 0
+ 1.3747500000000001e-06 0
+ 1.375e-06 0
+ 1.3752500000000001e-06 0
+ 1.3755e-06 0
+ 1.3757499999999999e-06 0
+ 1.376e-06 0
+ 1.37625e-06 0
+ 1.3765000000000001e-06 0
+ 1.37675e-06 0
+ 1.3769999999999999e-06 0
+ 1.37725e-06 0
+ 1.3774999999999999e-06 0
+ 1.3777500000000001e-06 0
+ 1.378e-06 0
+ 1.3782500000000001e-06 0
+ 1.3785e-06 0
+ 1.3787499999999999e-06 0
+ 1.3790000000000001e-06 0
+ 1.37925e-06 0
+ 1.3795000000000001e-06 0
+ 1.37975e-06 0
+ 1.3799999999999999e-06 0
+ 1.38025e-06 0
+ 1.3805e-06 0
+ 1.3807500000000001e-06 0
+ 1.381e-06 0
+ 1.3812499999999999e-06 0
+ 1.3815e-06 0
+ 1.3817499999999999e-06 0
+ 1.3820000000000001e-06 0
+ 1.38225e-06 0
+ 1.3825000000000001e-06 0
+ 1.38275e-06 0
+ 1.3829999999999999e-06 0
+ 1.3832500000000001e-06 0
+ 1.3835e-06 0
+ 1.3837500000000001e-06 0
+ 1.384e-06 0
+ 1.3842499999999999e-06 0
+ 1.3845e-06 0
+ 1.38475e-06 0
+ 1.3850000000000001e-06 0
+ 1.38525e-06 0
+ 1.3854999999999999e-06 0
+ 1.38575e-06 0
+ 1.3859999999999999e-06 0
+ 1.3862500000000001e-06 0
+ 1.3865e-06 0
+ 1.3867500000000001e-06 0
+ 1.387e-06 0
+ 1.3872499999999999e-06 0
+ 1.3875000000000001e-06 0
+ 1.38775e-06 0
+ 1.3880000000000001e-06 0
+ 1.38825e-06 0
+ 1.3884999999999999e-06 0
+ 1.38875e-06 0
+ 1.389e-06 0
+ 1.3892500000000001e-06 0
+ 1.3895e-06 0
+ 1.3897499999999999e-06 0
+ 1.39e-06 0
+ 1.3902499999999999e-06 0
+ 1.3905000000000001e-06 0
+ 1.39075e-06 0
+ 1.3909999999999999e-06 0
+ 1.39125e-06 0
+ 1.3914999999999999e-06 0
+ 1.3917500000000001e-06 0
+ 1.392e-06 0
+ 1.3922500000000001e-06 0
+ 1.3925e-06 0
+ 1.3927499999999999e-06 0
+ 1.393e-06 0
+ 1.39325e-06 0
+ 1.3935000000000001e-06 0
+ 1.39375e-06 0
+ 1.3939999999999999e-06 0
+ 1.39425e-06 0
+ 1.3944999999999999e-06 0
+ 1.3947500000000001e-06 0
+ 1.395e-06 0
+ 1.3952499999999999e-06 0
+ 1.3955e-06 0
+ 1.3957499999999999e-06 0
+ 1.3960000000000001e-06 0
+ 1.39625e-06 0
+ 1.3965000000000001e-06 0
+ 1.39675e-06 0
+ 1.3969999999999999e-06 0
+ 1.39725e-06 0
+ 1.3975e-06 0
+ 1.3977500000000001e-06 0
+ 1.398e-06 0
+ 1.3982499999999999e-06 0
+ 1.3985e-06 0
+ 1.3987499999999999e-06 0
+ 1.3990000000000001e-06 0
+ 1.39925e-06 0
+ 1.3994999999999999e-06 0
+ 1.39975e-06 0
+ 1.3999999999999999e-06 0
+ 1.4002500000000001e-06 0
+ 1.4005e-06 0
+ 1.4007500000000001e-06 0
+ 1.401e-06 0
+ 1.4012499999999999e-06 0
+ 1.4015e-06 0
+ 1.40175e-06 0
+ 1.4020000000000001e-06 0
+ 1.40225e-06 0
+ 1.4024999999999999e-06 0
+ 1.40275e-06 0
+ 1.403e-06 0
+ 1.4032500000000001e-06 0
+ 1.4035e-06 0
+ 1.4037499999999999e-06 0
+ 1.404e-06 0
+ 1.4042499999999999e-06 0
+ 1.4045000000000001e-06 0
+ 1.40475e-06 0
+ 1.4050000000000001e-06 0
+ 1.40525e-06 0
+ 1.4054999999999999e-06 0
+ 1.4057500000000001e-06 0
+ 1.406e-06 0
+ 1.4062500000000001e-06 0
+ 1.4065e-06 0
+ 1.4067499999999999e-06 0
+ 1.407e-06 0
+ 1.40725e-06 0
+ 1.4075000000000001e-06 0
+ 1.40775e-06 0
+ 1.4079999999999999e-06 0
+ 1.40825e-06 0
+ 1.4084999999999999e-06 0
+ 1.4087500000000001e-06 0
+ 1.409e-06 0
+ 1.4092500000000001e-06 0
+ 1.4095e-06 0
+ 1.4097499999999999e-06 0
+ 1.4100000000000001e-06 0
+ 1.41025e-06 0
+ 1.4105000000000001e-06 0
+ 1.41075e-06 0
+ 1.4109999999999999e-06 0
+ 1.41125e-06 0
+ 1.4115e-06 0
+ 1.4117500000000001e-06 0
+ 1.412e-06 0
+ 1.4122499999999999e-06 0
+ 1.4125e-06 0
+ 1.4127499999999999e-06 0
+ 1.4130000000000001e-06 0
+ 1.41325e-06 0
+ 1.4135000000000001e-06 0
+ 1.41375e-06 0
+ 1.4139999999999999e-06 0
+ 1.4142500000000001e-06 0
+ 1.4145e-06 0
+ 1.4147500000000001e-06 0
+ 1.415e-06 0
+ 1.4152499999999999e-06 0
+ 1.4155e-06 0
+ 1.41575e-06 0
+ 1.4160000000000001e-06 0
+ 1.41625e-06 0
+ 1.4164999999999999e-06 0
+ 1.41675e-06 0
+ 1.4169999999999999e-06 0
+ 1.4172500000000001e-06 0
+ 1.4175e-06 0
+ 1.4177500000000001e-06 0
+ 1.418e-06 0
+ 1.4182499999999999e-06 0
+ 1.4185000000000001e-06 0
+ 1.41875e-06 0
+ 1.4190000000000001e-06 0
+ 1.41925e-06 0
+ 1.4194999999999999e-06 0
+ 1.41975e-06 0
+ 1.42e-06 0
+ 1.4202500000000001e-06 0
+ 1.4205e-06 0
+ 1.4207499999999999e-06 0
+ 1.421e-06 0
+ 1.4212499999999999e-06 0
+ 1.4215000000000001e-06 0
+ 1.42175e-06 0
+ 1.4219999999999999e-06 0
+ 1.42225e-06 0
+ 1.4224999999999999e-06 0
+ 1.4227500000000001e-06 0
+ 1.423e-06 0
+ 1.4232500000000001e-06 0
+ 1.4235e-06 0
+ 1.4237499999999999e-06 0
+ 1.424e-06 0
+ 1.42425e-06 0
+ 1.4245000000000001e-06 0
+ 1.42475e-06 0
+ 1.4249999999999999e-06 0
+ 1.42525e-06 0
+ 1.4254999999999999e-06 0
+ 1.4257500000000001e-06 0
+ 1.426e-06 0
+ 1.4262499999999999e-06 0
+ 1.4265e-06 0
+ 1.4267499999999999e-06 0
+ 1.4270000000000001e-06 0
+ 1.42725e-06 0
+ 1.4275000000000001e-06 0
+ 1.42775e-06 0
+ 1.4279999999999999e-06 0
+ 1.42825e-06 0
+ 1.4285e-06 0
+ 1.4287500000000001e-06 0
+ 1.429e-06 0
+ 1.4292499999999999e-06 0
+ 1.4295e-06 0
+ 1.4297499999999999e-06 0
+ 1.4300000000000001e-06 0
+ 1.43025e-06 0
+ 1.4304999999999999e-06 0
+ 1.43075e-06 0
+ 1.4309999999999999e-06 0
+ 1.4312500000000001e-06 0
+ 1.4315e-06 0
+ 1.4317500000000001e-06 0
+ 1.432e-06 0
+ 1.4322499999999999e-06 0
+ 1.4325e-06 0
+ 1.43275e-06 0
+ 1.4330000000000001e-06 0
+ 1.43325e-06 0
+ 1.4334999999999999e-06 0
+ 1.43375e-06 0
+ 1.4339999999999999e-06 0
+ 1.4342500000000001e-06 0
+ 1.4345e-06 0
+ 1.4347499999999999e-06 0
+ 1.435e-06 0
+ 1.4352499999999999e-06 0
+ 1.4355000000000001e-06 0
+ 1.43575e-06 0
+ 1.4360000000000001e-06 0
+ 1.43625e-06 0
+ 1.4364999999999999e-06 0
+ 1.4367500000000001e-06 0
+ 1.437e-06 0
+ 1.4372500000000001e-06 0
+ 1.4375e-06 0
+ 1.4377499999999999e-06 0
+ 1.438e-06 0
+ 1.43825e-06 0
+ 1.4385000000000001e-06 0
+ 1.43875e-06 0
+ 1.4389999999999999e-06 0
+ 1.43925e-06 0
+ 1.4394999999999999e-06 0
+ 1.4397500000000001e-06 0
+ 1.44e-06 0
+ 1.4402500000000001e-06 0
+ 1.4405e-06 0
+ 1.4407499999999999e-06 0
+ 1.4410000000000001e-06 0
+ 1.44125e-06 0
+ 1.4415000000000001e-06 0
+ 1.44175e-06 0
+ 1.4419999999999999e-06 0
+ 1.44225e-06 0
+ 1.4425e-06 0
+ 1.4427500000000001e-06 0
+ 1.443e-06 0
+ 1.4432499999999999e-06 0
+ 1.4435e-06 0
+ 1.4437499999999999e-06 0
+ 1.4440000000000001e-06 0
+ 1.44425e-06 0
+ 1.4445000000000001e-06 0
+ 1.44475e-06 0
+ 1.4449999999999999e-06 0
+ 1.4452500000000001e-06 0
+ 1.4455e-06 0
+ 1.4457500000000001e-06 0
+ 1.446e-06 0
+ 1.4462499999999999e-06 0
+ 1.4465e-06 0
+ 1.44675e-06 0
+ 1.4470000000000001e-06 0
+ 1.44725e-06 0
+ 1.4474999999999999e-06 0
+ 1.44775e-06 0
+ 1.4479999999999999e-06 0
+ 1.4482500000000001e-06 0
+ 1.4485e-06 0
+ 1.4487500000000001e-06 0
+ 1.449e-06 0
+ 1.4492499999999999e-06 0
+ 1.4495000000000001e-06 0
+ 1.44975e-06 0
+ 1.4500000000000001e-06 0
+ 1.45025e-06 0
+ 1.4504999999999999e-06 0
+ 1.45075e-06 0
+ 1.451e-06 0
+ 1.4512500000000001e-06 0
+ 1.4515e-06 0
+ 1.4517499999999999e-06 0
+ 1.452e-06 0
+ 1.4522499999999999e-06 0
+ 1.4525000000000001e-06 0
+ 1.45275e-06 0
+ 1.4529999999999999e-06 0
+ 1.45325e-06 0
+ 1.4534999999999999e-06 0
+ 1.4537500000000001e-06 0
+ 1.454e-06 0
+ 1.4542500000000001e-06 0
+ 1.4545e-06 0
+ 1.4547499999999999e-06 0
+ 1.455e-06 0
+ 1.45525e-06 0
+ 1.4555000000000001e-06 0
+ 1.45575e-06 0
+ 1.4559999999999999e-06 0
+ 1.45625e-06 0
+ 1.4564999999999999e-06 0
+ 1.4567500000000001e-06 0
+ 1.457e-06 0
+ 1.4572499999999999e-06 0
+ 1.4575e-06 0
+ 1.4577499999999999e-06 0
+ 1.4580000000000001e-06 0
+ 1.45825e-06 0
+ 1.4585000000000001e-06 0
+ 1.45875e-06 0
+ 1.4589999999999999e-06 0
+ 1.45925e-06 0
+ 1.4595e-06 0
+ 1.4597500000000001e-06 0
+ 1.46e-06 0
+ 1.4602499999999999e-06 0
+ 1.4605e-06 0
+ 1.4607499999999999e-06 0
+ 1.4610000000000001e-06 0
+ 1.46125e-06 0
+ 1.4614999999999999e-06 0
+ 1.46175e-06 0
+ 1.4619999999999999e-06 0
+ 1.4622500000000001e-06 0
+ 1.4625e-06 0
+ 1.4627500000000001e-06 0
+ 1.463e-06 0
+ 1.4632499999999999e-06 0
+ 1.4635e-06 0
+ 1.46375e-06 0
+ 1.4640000000000001e-06 0
+ 1.46425e-06 0
+ 1.4644999999999999e-06 0
+ 1.46475e-06 0
+ 1.4649999999999999e-06 0
+ 1.4652500000000001e-06 0
+ 1.4655e-06 0
+ 1.4657499999999999e-06 0
+ 1.466e-06 0
+ 1.4662499999999999e-06 0
+ 1.4665000000000001e-06 0
+ 1.46675e-06 0
+ 1.4670000000000001e-06 0
+ 1.46725e-06 0
+ 1.4674999999999999e-06 0
+ 1.4677500000000001e-06 0
+ 1.468e-06 0
+ 1.4682500000000001e-06 0
+ 1.4685e-06 0
+ 1.4687499999999999e-06 0
+ 1.469e-06 0
+ 1.46925e-06 0
+ 1.4695000000000001e-06 0
+ 1.46975e-06 0
+ 1.4699999999999999e-06 0
+ 1.47025e-06 0
+ 1.4704999999999999e-06 0
+ 1.4707500000000001e-06 0
+ 1.471e-06 0
+ 1.4712500000000001e-06 0
+ 1.4715e-06 0
+ 1.4717499999999999e-06 0
+ 1.4720000000000001e-06 0
+ 1.47225e-06 0
+ 1.4725000000000001e-06 0
+ 1.47275e-06 0
+ 1.4729999999999999e-06 0
+ 1.47325e-06 0
+ 1.4735e-06 0
+ 1.4737500000000001e-06 0
+ 1.474e-06 0
+ 1.4742499999999999e-06 0
+ 1.4745e-06 0
+ 1.4747499999999999e-06 0
+ 1.4750000000000001e-06 0
+ 1.47525e-06 0
+ 1.4755000000000001e-06 0
+ 1.47575e-06 0
+ 1.4759999999999999e-06 0
+ 1.4762500000000001e-06 0
+ 1.4765e-06 0
+ 1.4767500000000001e-06 0
+ 1.477e-06 0
+ 1.4772499999999999e-06 0
+ 1.4775e-06 0
+ 1.47775e-06 0
+ 1.4780000000000001e-06 0
+ 1.47825e-06 0
+ 1.4784999999999999e-06 0
+ 1.47875e-06 0
+ 1.4789999999999999e-06 0
+ 1.4792500000000001e-06 0
+ 1.4795e-06 0
+ 1.4797500000000001e-06 0
+ 1.48e-06 0
+ 1.4802499999999999e-06 0
+ 1.4805000000000001e-06 0
+ 1.48075e-06 0
+ 1.4810000000000001e-06 0
+ 1.48125e-06 0
+ 1.4814999999999999e-06 0
+ 1.48175e-06 0
+ 1.482e-06 0
+ 1.4822500000000001e-06 0
+ 1.4825e-06 0
+ 1.4827499999999999e-06 0
+ 1.483e-06 0
+ 1.4832499999999999e-06 0
+ 1.4835000000000001e-06 0
+ 1.48375e-06 0
+ 1.4839999999999999e-06 0
+ 1.48425e-06 0
+ 1.4844999999999999e-06 0
+ 1.4847500000000001e-06 0
+ 1.485e-06 0
+ 1.4852500000000001e-06 0
+ 1.4855e-06 0
+ 1.4857499999999999e-06 0
+ 1.486e-06 0
+ 1.48625e-06 0
+ 1.4865000000000001e-06 0
+ 1.48675e-06 0
+ 1.4869999999999999e-06 0
+ 1.48725e-06 0
+ 1.4874999999999999e-06 0
+ 1.4877500000000001e-06 0
+ 1.488e-06 0
+ 1.4882499999999999e-06 0
+ 1.4885e-06 0
+ 1.4887499999999999e-06 0
+ 1.4890000000000001e-06 0
+ 1.48925e-06 0
+ 1.4895000000000001e-06 0
+ 1.48975e-06 0
+ 1.4899999999999999e-06 0
+ 1.49025e-06 0
+ 1.4905e-06 0
+ 1.4907500000000001e-06 0
+ 1.491e-06 0
+ 1.4912499999999999e-06 0
+ 1.4915e-06 0
+ 1.4917499999999999e-06 0
+ 1.4920000000000001e-06 0
+ 1.49225e-06 0
+ 1.4924999999999999e-06 0
+ 1.49275e-06 0
+ 1.4929999999999999e-06 0
+ 1.4932500000000001e-06 0
+ 1.4935e-06 0
+ 1.4937500000000001e-06 0
+ 1.494e-06 0
+ 1.4942499999999999e-06 0
+ 1.4945e-06 0
+ 1.49475e-06 0
+ 1.4950000000000001e-06 0
+ 1.49525e-06 0
+ 1.4954999999999999e-06 0
+ 1.49575e-06 0
+ 1.4959999999999999e-06 0
+ 1.4962500000000001e-06 0
+ 1.4965e-06 0
+ 1.4967499999999999e-06 0
+ 1.497e-06 0
+ 1.4972499999999999e-06 0
+ 1.4975000000000001e-06 0
+ 1.49775e-06 0
+ 1.4980000000000001e-06 0
+ 1.49825e-06 0
+ 1.4984999999999999e-06 0
+ 1.49875e-06 0
+ 1.499e-06 0
+ 1.4992500000000001e-06 0
+ 1.4995e-06 0
+ 1.4997499999999999e-06 0
+ 1.5e-06 0
+ 1.50025e-06 0
+ 1.5005000000000001e-06 0
+ 1.50075e-06 0
+ 1.5009999999999999e-06 0
+ 1.50125e-06 0
+ 1.5014999999999999e-06 0
+ 1.5017500000000001e-06 0
+ 1.502e-06 0
+ 1.5022500000000001e-06 0
+ 1.5025e-06 0
+ 1.5027499999999999e-06 0
+ 1.5030000000000001e-06 0
+ 1.50325e-06 0
+ 1.5035000000000001e-06 0
+ 1.50375e-06 0
+ 1.5039999999999999e-06 0
+ 1.50425e-06 0
+ 1.5045e-06 0
+ 1.5047500000000001e-06 0
+ 1.505e-06 0
+ 1.5052499999999999e-06 0
+ 1.5055e-06 0
+ 1.5057499999999999e-06 0
+ 1.5060000000000001e-06 0
+ 1.50625e-06 0
+ 1.5065000000000001e-06 0
+ 1.50675e-06 0
+ 1.5069999999999999e-06 0
+ 1.5072500000000001e-06 0
+ 1.5075e-06 0
+ 1.5077500000000001e-06 0
+ 1.508e-06 0
+ 1.5082499999999999e-06 0
+ 1.5085e-06 0
+ 1.50875e-06 0
+ 1.5090000000000001e-06 0
+ 1.50925e-06 0
+ 1.5094999999999999e-06 0
+ 1.50975e-06 0
+ 1.5099999999999999e-06 0
+ 1.5102500000000001e-06 0
+ 1.5105e-06 0
+ 1.5107500000000001e-06 0
+ 1.511e-06 0
+ 1.5112499999999999e-06 0
+ 1.5115000000000001e-06 0
+ 1.51175e-06 0
+ 1.5120000000000001e-06 0
+ 1.51225e-06 0
+ 1.5124999999999999e-06 0
+ 1.51275e-06 0
+ 1.513e-06 0
+ 1.5132500000000001e-06 0
+ 1.5135e-06 0
+ 1.5137499999999999e-06 0
+ 1.514e-06 0
+ 1.5142499999999999e-06 0
+ 1.5145000000000001e-06 0
+ 1.51475e-06 0
+ 1.5149999999999999e-06 0
+ 1.51525e-06 0
+ 1.5154999999999999e-06 0
+ 1.5157500000000001e-06 0
+ 1.516e-06 0
+ 1.5162500000000001e-06 0
+ 1.5165e-06 0
+ 1.5167499999999999e-06 0
+ 1.517e-06 0
+ 1.51725e-06 0
+ 1.5175000000000001e-06 0
+ 1.51775e-06 0
+ 1.5179999999999999e-06 0
+ 1.51825e-06 0
+ 1.5184999999999999e-06 0
+ 1.5187500000000001e-06 0
+ 1.519e-06 0
+ 1.5192499999999999e-06 0
+ 1.5195e-06 0
+ 1.5197499999999999e-06 0
+ 1.5200000000000001e-06 0
+ 1.52025e-06 0
+ 1.5205000000000001e-06 0
+ 1.52075e-06 0
+ 1.5209999999999999e-06 0
+ 1.52125e-06 0
+ 1.5215e-06 0
+ 1.5217500000000001e-06 0
+ 1.522e-06 0
+ 1.5222499999999999e-06 0
+ 1.5225e-06 0
+ 1.5227499999999999e-06 0
+ 1.5230000000000001e-06 0
+ 1.52325e-06 0
+ 1.5234999999999999e-06 0
+ 1.52375e-06 0
+ 1.5239999999999999e-06 0
+ 1.5242500000000001e-06 0
+ 1.5245e-06 0
+ 1.5247500000000001e-06 0
+ 1.525e-06 0
+ 1.5252499999999999e-06 0
+ 1.5255e-06 0
+ 1.52575e-06 0
+ 1.5260000000000001e-06 0
+ 1.52625e-06 0
+ 1.5264999999999999e-06 0
+ 1.52675e-06 0
+ 1.5269999999999999e-06 0
+ 1.5272500000000001e-06 0
+ 1.5275e-06 0
+ 1.5277499999999999e-06 0
+ 1.528e-06 0
+ 1.5282499999999999e-06 0
+ 1.5285000000000001e-06 0
+ 1.52875e-06 0
+ 1.5290000000000001e-06 0
+ 1.52925e-06 0
+ 1.5294999999999999e-06 0
+ 1.52975e-06 0
+ 1.53e-06 0
+ 1.5302500000000001e-06 0
+ 1.5305e-06 0
+ 1.5307499999999999e-06 0
+ 1.531e-06 0
+ 1.53125e-06 0
+ 1.5315000000000001e-06 0
+ 1.53175e-06 0
+ 1.5319999999999999e-06 0
+ 1.53225e-06 0
+ 1.5324999999999999e-06 0
+ 1.5327500000000001e-06 0
+ 1.533e-06 0
+ 1.5332500000000001e-06 0
+ 1.5335e-06 0
+ 1.5337499999999999e-06 0
+ 1.5340000000000001e-06 0
+ 1.53425e-06 0
+ 1.5345000000000001e-06 0
+ 1.53475e-06 0
+ 1.5349999999999999e-06 0
+ 1.53525e-06 0
+ 1.5355e-06 0
+ 1.5357500000000001e-06 0
+ 1.536e-06 0
+ 1.5362499999999999e-06 0
+ 1.5365e-06 0
+ 1.5367499999999999e-06 0
+ 1.5370000000000001e-06 0
+ 1.53725e-06 0
+ 1.5375000000000001e-06 0
+ 1.53775e-06 0
+ 1.5379999999999999e-06 0
+ 1.5382500000000001e-06 0
+ 1.5385e-06 0
+ 1.5387500000000001e-06 0
+ 1.539e-06 0
+ 1.5392499999999999e-06 0
+ 1.5395e-06 0
+ 1.53975e-06 0
+ 1.5400000000000001e-06 0
+ 1.54025e-06 0
+ 1.5404999999999999e-06 0
+ 1.54075e-06 0
+ 1.5409999999999999e-06 0
+ 1.5412500000000001e-06 0
+ 1.5415e-06 0
+ 1.5417500000000001e-06 0
+ 1.542e-06 0
+ 1.5422499999999999e-06 0
+ 1.5425000000000001e-06 0
+ 1.54275e-06 0
+ 1.5430000000000001e-06 0
+ 1.54325e-06 0
+ 1.5434999999999999e-06 0
+ 1.54375e-06 0
+ 1.544e-06 0
+ 1.5442500000000001e-06 0
+ 1.5445e-06 0
+ 1.5447499999999999e-06 0
+ 1.545e-06 0
+ 1.5452499999999999e-06 0
+ 1.5455000000000001e-06 0
+ 1.54575e-06 0
+ 1.5460000000000001e-06 0
+ 1.54625e-06 0
+ 1.5464999999999999e-06 0
+ 1.5467500000000001e-06 0
+ 1.547e-06 0
+ 1.5472500000000001e-06 0
+ 1.5475e-06 0
+ 1.5477499999999999e-06 0
+ 1.548e-06 0
+ 1.54825e-06 0
+ 1.5485000000000001e-06 0
+ 1.54875e-06 0
+ 1.5489999999999999e-06 0
+ 1.54925e-06 0
+ 1.5494999999999999e-06 0
+ 1.5497500000000001e-06 0
+ 1.55e-06 0
+ 1.5502499999999999e-06 0
+ 1.5505e-06 0
+ 1.5507499999999999e-06 0
+ 1.5510000000000001e-06 0
+ 1.55125e-06 0
+ 1.5515000000000001e-06 0
+ 1.55175e-06 0
+ 1.5519999999999999e-06 0
+ 1.55225e-06 0
+ 1.5525e-06 0
+ 1.5527500000000001e-06 0
+ 1.553e-06 0
+ 1.5532499999999999e-06 0
+ 1.5535e-06 0
+ 1.5537499999999999e-06 0
+ 1.5540000000000001e-06 0
+ 1.55425e-06 0
+ 1.5544999999999999e-06 0
+ 1.55475e-06 0
+ 1.5549999999999999e-06 0
+ 1.5552500000000001e-06 0
+ 1.5555e-06 0
+ 1.5557500000000001e-06 0
+ 1.556e-06 0
+ 1.5562499999999999e-06 0
+ 1.5565e-06 0
+ 1.55675e-06 0
+ 1.5570000000000001e-06 0
+ 1.55725e-06 0
+ 1.5574999999999999e-06 0
+ 1.55775e-06 0
+ 1.5579999999999999e-06 0
+ 1.5582500000000001e-06 0
+ 1.5585e-06 0
+ 1.5587499999999999e-06 0
+ 1.559e-06 0
+ 1.5592499999999999e-06 0
+ 1.5595000000000001e-06 0
+ 1.55975e-06 0
+ 1.5600000000000001e-06 0
+ 1.56025e-06 0
+ 1.5604999999999999e-06 0
+ 1.56075e-06 0
+ 1.561e-06 0
+ 1.5612500000000001e-06 0
+ 1.5615e-06 0
+ 1.5617499999999999e-06 0
+ 1.562e-06 0
+ 1.56225e-06 0
+ 1.5625000000000001e-06 0
+ 1.56275e-06 0
+ 1.5629999999999999e-06 0
+ 1.56325e-06 0
+ 1.5634999999999999e-06 0
+ 1.5637500000000001e-06 0
+ 1.564e-06 0
+ 1.5642500000000001e-06 0
+ 1.5645e-06 0
+ 1.5647499999999999e-06 0
+ 1.5650000000000001e-06 0
+ 1.56525e-06 0
+ 1.5655000000000001e-06 0
+ 1.56575e-06 0
+ 1.5659999999999999e-06 0
+ 1.56625e-06 0
+ 1.5665e-06 0
+ 1.5667500000000001e-06 0
+ 1.567e-06 0
+ 1.5672499999999999e-06 0
+ 1.5675e-06 0
+ 1.5677499999999999e-06 0
+ 1.5680000000000001e-06 0
+ 1.56825e-06 0
+ 1.5685000000000001e-06 0
+ 1.56875e-06 0
+ 1.5689999999999999e-06 0
+ 1.5692500000000001e-06 0
+ 1.5695e-06 0
+ 1.5697500000000001e-06 0
+ 1.57e-06 0
+ 1.5702499999999999e-06 0
+ 1.5705e-06 0
+ 1.57075e-06 0
+ 1.5710000000000001e-06 0
+ 1.57125e-06 0
+ 1.5714999999999999e-06 0
+ 1.57175e-06 0
+ 1.5719999999999999e-06 0
+ 1.5722500000000001e-06 0
+ 1.5725e-06 0
+ 1.5727500000000001e-06 0
+ 1.573e-06 0
+ 1.5732499999999999e-06 0
+ 1.5735000000000001e-06 0
+ 1.57375e-06 0
+ 1.5740000000000001e-06 0
+ 1.57425e-06 0
+ 1.5744999999999999e-06 0
+ 1.57475e-06 0
+ 1.575e-06 0
+ 1.5752500000000001e-06 0
+ 1.5755e-06 0
+ 1.5757499999999999e-06 0
+ 1.576e-06 0
+ 1.5762499999999999e-06 0
+ 1.5765000000000001e-06 0
+ 1.57675e-06 0
+ 1.5770000000000001e-06 0
+ 1.57725e-06 0
+ 1.5774999999999999e-06 0
+ 1.5777500000000001e-06 0
+ 1.578e-06 0
+ 1.5782500000000001e-06 0
+ 1.5785e-06 0
+ 1.5787499999999999e-06 0
+ 1.579e-06 0
+ 1.57925e-06 0
+ 1.5794920000000001e-06 0
+ 1.5795000000000001e-06 0
+ 1.57975e-06 0
+ 1.5799999999999999e-06 0
+ 1.58025e-06 0
+ 1.5804999999999999e-06 0
+ 1.5807500000000001e-06 0
+ 1.581e-06 0
+ 1.5812499999999999e-06 0
+ 1.5815e-06 0
+ 1.5817499999999999e-06 0
+ 1.5820000000000001e-06 0
+ 1.58225e-06 0
+ 1.5825000000000001e-06 0
+ 1.58275e-06 0
+ 1.5829999999999999e-06 0
+ 1.58325e-06 0
+ 1.5835e-06 0
+ 1.5837500000000001e-06 0
+ 1.584e-06 0
+ 1.5842499999999999e-06 0
+ 1.5845e-06 0
+ 1.5847499999999999e-06 0
+ 1.5850000000000001e-06 0
+ 1.58525e-06 0
+ 1.5854999999999999e-06 0
+ 1.58575e-06 0
+ 1.5859999999999999e-06 0
+ 1.5862500000000001e-06 0
+ 1.5865e-06 0
+ 1.5867500000000001e-06 0
+ 1.587e-06 0
+ 1.5872499999999999e-06 0
+ 1.5875e-06 0
+ 1.58775e-06 0
+ 1.5880000000000001e-06 0
+ 1.58825e-06 0
+ 1.5884999999999999e-06 0
+ 1.58875e-06 0
+ 1.5889999999999999e-06 0
+ 1.5892500000000001e-06 0
+ 1.5895e-06 0
+ 1.5897499999999999e-06 0
+ 1.59e-06 0
+ 1.5902499999999999e-06 0
+ 1.5905000000000001e-06 0
+ 1.59075e-06 0
+ 1.5910000000000001e-06 0
+ 1.59125e-06 0
+ 1.5914999999999999e-06 0
+ 1.59175e-06 0
+ 1.592e-06 0
+ 1.5922500000000001e-06 0
+ 1.5925e-06 0
+ 1.5927499999999999e-06 0
+ 1.593e-06 0
+ 1.5932499999999999e-06 0
+ 1.5935000000000001e-06 0
+ 1.59375e-06 0
+ 1.5939999999999999e-06 0
+ 1.59425e-06 0
+ 1.5944999999999999e-06 0
+ 1.5947500000000001e-06 0
+ 1.595e-06 0
+ 1.5952500000000001e-06 0
+ 1.5955e-06 0
+ 1.5957499999999999e-06 0
+ 1.5960000000000001e-06 0
+ 1.59625e-06 0
+ 1.5965000000000001e-06 0
+ 1.59675e-06 0
+ 1.5969999999999999e-06 0
+ 1.59725e-06 0
+ 1.5975e-06 0
+ 1.5977500000000001e-06 0
+ 1.598e-06 0
+ 1.5982499999999999e-06 0
+ 1.5985e-06 0
+ 1.5987499999999999e-06 0
+ 1.5990000000000001e-06 0
+ 1.59925e-06 0
+ 1.5995000000000001e-06 0
+ 1.59975e-06 0
+ 1.5999999999999999e-06 0
+ 1.6002500000000001e-06 0
+ 1.6005e-06 0
+ 1.6007500000000001e-06 0
+ 1.601e-06 0
+ 1.6012499999999999e-06 0
+ 1.6015e-06 0
+ 1.60175e-06 0
+ 1.6020000000000001e-06 0
+ 1.60225e-06 0
+ 1.6024999999999999e-06 0
+ 1.60275e-06 0
+ 1.6029999999999999e-06 0
+ 1.6032500000000001e-06 0
+ 1.6035e-06 0
+ 1.6037500000000001e-06 0
+ 1.604e-06 0
+ 1.6042499999999999e-06 0
+ 1.6045000000000001e-06 0
+ 1.60475e-06 0
+ 1.6050000000000001e-06 0
+ 1.60525e-06 0
+ 1.6054999999999999e-06 0
+ 1.60575e-06 0
+ 1.606e-06 0
+ 1.6062500000000001e-06 0
+ 1.6065e-06 0
+ 1.6067499999999999e-06 0
+ 1.607e-06 0
+ 1.6072499999999999e-06 0
+ 1.6075000000000001e-06 0
+ 1.60775e-06 0
+ 1.6080000000000001e-06 0
+ 1.60825e-06 0
+ 1.6084999999999999e-06 0
+ 1.6087500000000001e-06 0
+ 1.609e-06 0
+ 1.6092500000000001e-06 0
+ 1.6095e-06 0
+ 1.6097499999999999e-06 0
+ 1.61e-06 0
+ 1.61025e-06 0
+ 1.6105000000000001e-06 0
+ 1.61075e-06 0
+ 1.6109999999999999e-06 0
+ 1.61125e-06 0
+ 1.6114999999999999e-06 0
+ 1.6117500000000001e-06 0
+ 1.612e-06 0
+ 1.6122499999999999e-06 0
+ 1.6125e-06 0
+ 1.6127499999999999e-06 0
+ 1.6130000000000001e-06 0
+ 1.61325e-06 0
+ 1.6135000000000001e-06 0
+ 1.61375e-06 0
+ 1.6139999999999999e-06 0
+ 1.61425e-06 0
+ 1.6145e-06 0
+ 1.6147500000000001e-06 0
+ 1.615e-06 0
+ 1.6152499999999999e-06 0
+ 1.6155e-06 0
+ 1.6157499999999999e-06 0
+ 1.6160000000000001e-06 0
+ 1.61625e-06 0
+ 1.6164999999999999e-06 0
+ 1.61675e-06 0
+ 1.6169999999999999e-06 0
+ 1.6172500000000001e-06 0
+ 1.6175e-06 0
+ 1.6177500000000001e-06 0
+ 1.618e-06 0
+ 1.6182499999999999e-06 0
+ 1.6185e-06 0
+ 1.61875e-06 0
+ 1.6190000000000001e-06 0
+ 1.61925e-06 0
+ 1.6194999999999999e-06 0
+ 1.61975e-06 0
+ 1.6199999999999999e-06 0
+ 1.6202500000000001e-06 0
+ 1.6205e-06 0
+ 1.6207499999999999e-06 0
+ 1.621e-06 0
+ 1.6212499999999999e-06 0
+ 1.6215000000000001e-06 0
+ 1.62175e-06 0
+ 1.6220000000000001e-06 0
+ 1.62225e-06 0
+ 1.6224999999999999e-06 0
+ 1.62275e-06 0
+ 1.623e-06 0
+ 1.6232500000000001e-06 0
+ 1.6235e-06 0
+ 1.6237499999999999e-06 0
+ 1.624e-06 0
+ 1.6242499999999999e-06 0
+ 1.6245000000000001e-06 0
+ 1.62475e-06 0
+ 1.6249999999999999e-06 0
+ 1.62525e-06 0
+ 1.6254999999999999e-06 0
+ 1.6257500000000001e-06 0
+ 1.626e-06 0
+ 1.6262500000000001e-06 0
+ 1.6265e-06 0
+ 1.6267499999999999e-06 0
+ 1.6270000000000001e-06 0
+ 1.62725e-06 0
+ 1.6275000000000001e-06 0
+ 1.62775e-06 0
+ 1.6279999999999999e-06 0
+ 1.62825e-06 0
+ 1.6285e-06 0
+ 1.6287500000000001e-06 0
+ 1.629e-06 0
+ 1.6292499999999999e-06 0
+ 1.6295e-06 0
+ 1.6297499999999999e-06 0
+ 1.6300000000000001e-06 0
+ 1.63025e-06 0
+ 1.6305000000000001e-06 0
+ 1.63075e-06 0
+ 1.6309999999999999e-06 0
+ 1.6312500000000001e-06 0
+ 1.6315e-06 0
+ 1.6317500000000001e-06 0
+ 1.632e-06 0
+ 1.6322499999999999e-06 0
+ 1.6325e-06 0
+ 1.63275e-06 0
+ 1.6330000000000001e-06 0
+ 1.63325e-06 0
+ 1.6334999999999999e-06 0
+ 1.63375e-06 0
+ 1.6339999999999999e-06 0
+ 1.6342500000000001e-06 0
+ 1.6345e-06 0
+ 1.6347500000000001e-06 0
+ 1.635e-06 0
+ 1.6352499999999999e-06 0
+ 1.6355000000000001e-06 0
+ 1.63575e-06 0
+ 1.6360000000000001e-06 0
+ 1.63625e-06 0
+ 1.6364999999999999e-06 0
+ 1.63675e-06 0
+ 1.637e-06 0
+ 1.6372500000000001e-06 0
+ 1.6375e-06 0
+ 1.6377499999999999e-06 0
+ 1.638e-06 0
+ 1.6382499999999999e-06 0
+ 1.6385000000000001e-06 0
+ 1.63875e-06 0
+ 1.6390000000000001e-06 0
+ 1.63925e-06 0
+ 1.6394999999999999e-06 0
+ 1.6397500000000001e-06 0
+ 1.64e-06 0
+ 1.6402500000000001e-06 0
+ 1.6405e-06 0
+ 1.6407499999999999e-06 0
+ 1.641e-06 0
+ 1.64125e-06 0
+ 1.6415000000000001e-06 0
+ 1.64175e-06 0
+ 1.6419999999999999e-06 0
+ 1.64225e-06 0
+ 1.6424999999999999e-06 0
+ 1.6427500000000001e-06 0
+ 1.643e-06 0
+ 1.6432499999999999e-06 0
+ 1.6435e-06 0
+ 1.6437499999999999e-06 0
+ 1.6440000000000001e-06 0
+ 1.64425e-06 0
+ 1.6445000000000001e-06 0
+ 1.64475e-06 0
+ 1.6449999999999999e-06 0
+ 1.64525e-06 0
+ 1.6455e-06 0
+ 1.6457500000000001e-06 0
+ 1.646e-06 0
+ 1.6462499999999999e-06 0
+ 1.6465e-06 0
+ 1.6467499999999999e-06 0
+ 1.6470000000000001e-06 0
+ 1.64725e-06 0
+ 1.6474999999999999e-06 0
+ 1.64775e-06 0
+ 1.6479999999999999e-06 0
+ 1.6482500000000001e-06 0
+ 1.6485e-06 0
+ 1.6487500000000001e-06 0
+ 1.649e-06 0
+ 1.6492499999999999e-06 0
+ 1.6495e-06 0
+ 1.64975e-06 0
+ 1.6500000000000001e-06 0
+ 1.65025e-06 0
+ 1.6504999999999999e-06 0
+ 1.65075e-06 0
+ 1.6509999999999999e-06 0
+ 1.6512500000000001e-06 0
+ 1.6515e-06 0
+ 1.6517499999999999e-06 0
+ 1.652e-06 0
+ 1.6522499999999999e-06 0
+ 1.6525000000000001e-06 0
+ 1.65275e-06 0
+ 1.6530000000000001e-06 0
+ 1.65325e-06 0
+ 1.6534999999999999e-06 0
+ 1.65375e-06 0
+ 1.654e-06 0
+ 1.6542500000000001e-06 0
+ 1.6545e-06 0
+ 1.6547499999999999e-06 0
+ 1.655e-06 0
+ 1.6552499999999999e-06 0
+ 1.6555000000000001e-06 0
+ 1.65575e-06 0
+ 1.6559999999999999e-06 0
+ 1.65625e-06 0
+ 1.6564999999999999e-06 0
+ 1.6567500000000001e-06 0
+ 1.657e-06 0
+ 1.6572500000000001e-06 0
+ 1.6575e-06 0
+ 1.6577499999999999e-06 0
+ 1.658e-06 0
+ 1.65825e-06 0
+ 1.6585000000000001e-06 0
+ 1.65875e-06 0
+ 1.6589999999999999e-06 0
+ 1.65925e-06 0
+ 1.6595e-06 0
+ 1.6597500000000001e-06 0
+ 1.66e-06 0
+ 1.6602499999999999e-06 0
+ 1.6605e-06 0
+ 1.6607499999999999e-06 0
+ 1.6610000000000001e-06 0
+ 1.66125e-06 0
+ 1.6615000000000001e-06 0
+ 1.66175e-06 0
+ 1.6619999999999999e-06 0
+ 1.6622500000000001e-06 0
+ 1.6625e-06 0
+ 1.6627500000000001e-06 0
+ 1.663e-06 0
+ 1.6632499999999999e-06 0
+ 1.6635e-06 0
+ 1.66375e-06 0
+ 1.6640000000000001e-06 0
+ 1.66425e-06 0
+ 1.6644999999999999e-06 0
+ 1.66475e-06 0
+ 1.6649999999999999e-06 0
+ 1.6652500000000001e-06 0
+ 1.6655e-06 0
+ 1.6657500000000001e-06 0
+ 1.666e-06 0
+ 1.6662499999999999e-06 0
+ 1.6665000000000001e-06 0
+ 1.66675e-06 0
+ 1.6670000000000001e-06 0
+ 1.66725e-06 0
+ 1.6674999999999999e-06 0
+ 1.66775e-06 0
+ 1.668e-06 0
+ 1.6682500000000001e-06 0
+ 1.6685e-06 0
+ 1.6687499999999999e-06 0
+ 1.669e-06 0
+ 1.6692499999999999e-06 0
+ 1.6695000000000001e-06 0
+ 1.66975e-06 0
+ 1.6700000000000001e-06 0
+ 1.67025e-06 0
+ 1.6704999999999999e-06 0
+ 1.6707500000000001e-06 0
+ 1.671e-06 0
+ 1.6712500000000001e-06 0
+ 1.6715e-06 0
+ 1.6717499999999999e-06 0
+ 1.672e-06 0
+ 1.67225e-06 0
+ 1.6725000000000001e-06 0
+ 1.67275e-06 0
+ 1.6729999999999999e-06 0
+ 1.67325e-06 0
+ 1.6734999999999999e-06 0
+ 1.6737500000000001e-06 0
+ 1.674e-06 0
+ 1.6742499999999999e-06 0
+ 1.6745e-06 0
+ 1.6747499999999999e-06 0
+ 1.6750000000000001e-06 0
+ 1.67525e-06 0
+ 1.6755000000000001e-06 0
+ 1.67575e-06 0
+ 1.6759999999999999e-06 0
+ 1.67625e-06 0
+ 1.6765e-06 0
+ 1.6767500000000001e-06 0
+ 1.677e-06 0
+ 1.6772499999999999e-06 0
+ 1.6775e-06 0
+ 1.6777499999999999e-06 0
+ 1.6780000000000001e-06 0
+ 1.67825e-06 0
+ 1.6784999999999999e-06 0
+ 1.67875e-06 0
+ 1.6789999999999999e-06 0
+ 1.6792500000000001e-06 0
+ 1.6795e-06 0
+ 1.6797500000000001e-06 0
+ 1.68e-06 0
+ 1.6802499999999999e-06 0
+ 1.6805e-06 0
+ 1.68075e-06 0
+ 1.6810000000000001e-06 0
+ 1.68125e-06 0
+ 1.6814999999999999e-06 0
+ 1.68175e-06 0
+ 1.6819999999999999e-06 0
+ 1.6822500000000001e-06 0
+ 1.6825e-06 0
+ 1.6827499999999999e-06 0
+ 1.683e-06 0
+ 1.6832499999999999e-06 0
+ 1.6835000000000001e-06 0
+ 1.68375e-06 0
+ 1.6840000000000001e-06 0
+ 1.68425e-06 0
+ 1.6844999999999999e-06 0
+ 1.68475e-06 0
+ 1.685e-06 0
+ 1.6852500000000001e-06 0
+ 1.6855e-06 0
+ 1.6857499999999999e-06 0
+ 1.686e-06 0
+ 1.6862499999999999e-06 0
+ 1.6865000000000001e-06 0
+ 1.68675e-06 0
+ 1.6869999999999999e-06 0
+ 1.68725e-06 0
+ 1.6874999999999999e-06 0
+ 1.6877500000000001e-06 0
+ 1.688e-06 0
+ 1.6882500000000001e-06 0
+ 1.6885e-06 0
+ 1.6887499999999999e-06 0
+ 1.689e-06 0
+ 1.68925e-06 0
+ 1.6895000000000001e-06 0
+ 1.68975e-06 0
+ 1.6899999999999999e-06 0
+ 1.69025e-06 0
+ 1.6905e-06 0
+ 1.6907500000000001e-06 0
+ 1.691e-06 0
+ 1.6912499999999999e-06 0
+ 1.6915e-06 0
+ 1.6917499999999999e-06 0
+ 1.6920000000000001e-06 0
+ 1.69225e-06 0
+ 1.6925000000000001e-06 0
+ 1.69275e-06 0
+ 1.6929999999999999e-06 0
+ 1.6932500000000001e-06 0
+ 1.6935e-06 0
+ 1.6937500000000001e-06 0
+ 1.694e-06 0
+ 1.6942499999999999e-06 0
+ 1.6945e-06 0
+ 1.69475e-06 0
+ 1.6950000000000001e-06 0
+ 1.69525e-06 0
+ 1.6954999999999999e-06 0
+ 1.69575e-06 0
+ 1.6959999999999999e-06 0
+ 1.6962500000000001e-06 0
+ 1.6965e-06 0
+ 1.6967500000000001e-06 0
+ 1.697e-06 0
+ 1.6972499999999999e-06 0
+ 1.6975000000000001e-06 0
+ 1.69775e-06 0
+ 1.6980000000000001e-06 0
+ 1.69825e-06 0
+ 1.6984999999999999e-06 0
+ 1.69875e-06 0
+ 1.699e-06 0
+ 1.6992500000000001e-06 0
+ 1.6995e-06 0
+ 1.6997499999999999e-06 0
+ 1.7e-06 0
+ 1.7002499999999999e-06 0
+ 1.7005000000000001e-06 0
+ 1.70075e-06 0
+ 1.7010000000000001e-06 0
+ 1.70125e-06 0
+ 1.7014999999999999e-06 0
+ 1.7017500000000001e-06 0
+ 1.702e-06 0
+ 1.7022500000000001e-06 0
+ 1.7025e-06 0
+ 1.7027499999999999e-06 0
+ 1.703e-06 0
+ 1.70325e-06 0
+ 1.7035000000000001e-06 0
+ 1.70375e-06 0
+ 1.7039999999999999e-06 0
+ 1.70425e-06 0
+ 1.7044999999999999e-06 0
+ 1.7047500000000001e-06 0
+ 1.705e-06 0
+ 1.7052500000000001e-06 0
+ 1.7055e-06 0
+ 1.7057499999999999e-06 0
+ 1.7060000000000001e-06 0
+ 1.70625e-06 0
+ 1.7065000000000001e-06 0
+ 1.70675e-06 0
+ 1.7069999999999999e-06 0
+ 1.70725e-06 0
+ 1.7075e-06 0
+ 1.7077500000000001e-06 0
+ 1.708e-06 0
+ 1.7082499999999999e-06 0
+ 1.7085e-06 0
+ 1.7087499999999999e-06 0
+ 1.7090000000000001e-06 0
+ 1.70925e-06 0
+ 1.7094999999999999e-06 0
+ 1.70975e-06 0
+ 1.7099999999999999e-06 0
+ 1.7102500000000001e-06 0
+ 1.7105e-06 0
+ 1.7107500000000001e-06 0
+ 1.711e-06 0
+ 1.7112499999999999e-06 0
+ 1.7115e-06 0
+ 1.71175e-06 0
+ 1.7120000000000001e-06 0
+ 1.71225e-06 0
+ 1.7124999999999999e-06 0
+ 1.71275e-06 0
+ 1.7129999999999999e-06 0
+ 1.7132500000000001e-06 0
+ 1.7135e-06 0
+ 1.7137499999999999e-06 0
+ 1.714e-06 0
+ 1.7142499999999999e-06 0
+ 1.7145000000000001e-06 0
+ 1.71475e-06 0
+ 1.7150000000000001e-06 0
+ 1.71525e-06 0
+ 1.7154999999999999e-06 0
+ 1.71575e-06 0
+ 1.716e-06 0
+ 1.7162500000000001e-06 0
+ 1.7165e-06 0
+ 1.7167499999999999e-06 0
+ 1.717e-06 0
+ 1.7172499999999999e-06 0
+ 1.7175000000000001e-06 0
+ 1.71775e-06 0
+ 1.7179999999999999e-06 0
+ 1.71825e-06 0
+ 1.7184999999999999e-06 0
+ 1.7187500000000001e-06 0
+ 1.719e-06 0
+ 1.7192500000000001e-06 0
+ 1.7195e-06 0
+ 1.7197499999999999e-06 0
+ 1.72e-06 0
+ 1.72025e-06 0
+ 1.7205000000000001e-06 0
+ 1.72075e-06 0
+ 1.7209999999999999e-06 0
+ 1.72125e-06 0
+ 1.7215e-06 0
+ 1.7217500000000001e-06 0
+ 1.722e-06 0
+ 1.7222499999999999e-06 0
+ 1.7225e-06 0
+ 1.7227499999999999e-06 0
+ 1.7230000000000001e-06 0
+ 1.72325e-06 0
+ 1.7235000000000001e-06 0
+ 1.72375e-06 0
+ 1.7239999999999999e-06 0
+ 1.7242500000000001e-06 0
+ 1.7245e-06 0
+ 1.7247500000000001e-06 0
+ 1.725e-06 0
+ 1.7252499999999999e-06 0
+ 1.7255e-06 0
+ 1.72575e-06 0
+ 1.7260000000000001e-06 0
+ 1.72625e-06 0
+ 1.7264999999999999e-06 0
+ 1.72675e-06 0
+ 1.7269999999999999e-06 0
+ 1.7272500000000001e-06 0
+ 1.7275e-06 0
+ 1.7277500000000001e-06 0
+ 1.728e-06 0
+ 1.7282499999999999e-06 0
+ 1.7285000000000001e-06 0
+ 1.72875e-06 0
+ 1.7290000000000001e-06 0
+ 1.72925e-06 0
+ 1.7294999999999999e-06 0
+ 1.72975e-06 0
+ 1.73e-06 0
+ 1.7302500000000001e-06 0
+ 1.7305e-06 0
+ 1.7307499999999999e-06 0
+ 1.731e-06 0
+ 1.7312499999999999e-06 0
+ 1.7315000000000001e-06 0
+ 1.73175e-06 0
+ 1.7320000000000001e-06 0
+ 1.73225e-06 0
+ 1.7324999999999999e-06 0
+ 1.7327500000000001e-06 0
+ 1.733e-06 0
+ 1.7332500000000001e-06 0
+ 1.7335e-06 0
+ 1.7337499999999999e-06 0
+ 1.734e-06 0
+ 1.73425e-06 0
+ 1.7345000000000001e-06 0
+ 1.73475e-06 0
+ 1.7349999999999999e-06 0
+ 1.73525e-06 0
+ 1.7354999999999999e-06 0
+ 1.7357500000000001e-06 0
+ 1.736e-06 0
+ 1.7362500000000001e-06 0
+ 1.7365e-06 0
+ 1.7367499999999999e-06 0
+ 1.7370000000000001e-06 0
+ 1.73725e-06 0
+ 1.7375000000000001e-06 0
+ 1.73775e-06 0
+ 1.7379999999999999e-06 0
+ 1.73825e-06 0
+ 1.7385e-06 0
+ 1.7387500000000001e-06 0
+ 1.739e-06 0
+ 1.7392499999999999e-06 0
+ 1.7395e-06 0
+ 1.7397499999999999e-06 0
+ 1.7400000000000001e-06 0
+ 1.74025e-06 0
+ 1.7404999999999999e-06 0
+ 1.74075e-06 0
+ 1.7409999999999999e-06 0
+ 1.7412500000000001e-06 0
+ 1.7415e-06 0
+ 1.7417500000000001e-06 0
+ 1.742e-06 0
+ 1.7422499999999999e-06 0
+ 1.7425e-06 0
+ 1.74275e-06 0
+ 1.7430000000000001e-06 0
+ 1.74325e-06 0
+ 1.7434999999999999e-06 0
+ 1.74375e-06 0
+ 1.7439999999999999e-06 0
+ 1.7442500000000001e-06 0
+ 1.7445e-06 0
+ 1.7447499999999999e-06 0
+ 1.745e-06 0
+ 1.7452499999999999e-06 0
+ 1.7455000000000001e-06 0
+ 1.74575e-06 0
+ 1.7460000000000001e-06 0
+ 1.74625e-06 0
+ 1.7464999999999999e-06 0
+ 1.74675e-06 0
+ 1.747e-06 0
+ 1.7472500000000001e-06 0
+ 1.7475e-06 0
+ 1.7477499999999999e-06 0
+ 1.748e-06 0
+ 1.7482499999999999e-06 0
+ 1.7485000000000001e-06 0
+ 1.74875e-06 0
+ 1.7489999999999999e-06 0
+ 1.74925e-06 0
+ 1.7494999999999999e-06 0
+ 1.7497500000000001e-06 0
+ 1.75e-06 0
+ 1.7502500000000001e-06 0
+ 1.7505e-06 0
+ 1.7507499999999999e-06 0
+ 1.751e-06 0
+ 1.75125e-06 0
+ 1.7515000000000001e-06 0
+ 1.75175e-06 0
+ 1.7519999999999999e-06 0
+ 1.75225e-06 0
+ 1.7524999999999999e-06 0
+ 1.7527500000000001e-06 0
+ 1.753e-06 0
+ 1.7532499999999999e-06 0
+ 1.7535e-06 0
+ 1.7537499999999999e-06 0
+ 1.7540000000000001e-06 0
+ 1.75425e-06 0
+ 1.7545000000000001e-06 0
+ 1.75475e-06 0
+ 1.7549999999999999e-06 0
+ 1.7552500000000001e-06 0
+ 1.7555e-06 0
+ 1.7557500000000001e-06 0
+ 1.756e-06 0
+ 1.7562499999999999e-06 0
+ 1.7565e-06 0
+ 1.75675e-06 0
+ 1.7570000000000001e-06 0
+ 1.75725e-06 0
+ 1.7574999999999999e-06 0
+ 1.75775e-06 0
+ 1.7579999999999999e-06 0
+ 1.7582500000000001e-06 0
+ 1.7585e-06 0
+ 1.7587500000000001e-06 0
+ 1.759e-06 0
+ 1.7592499999999999e-06 0
+ 1.7595000000000001e-06 0
+ 1.75975e-06 0
+ 1.7600000000000001e-06 0
+ 1.76025e-06 0
+ 1.7604999999999999e-06 0
+ 1.76075e-06 0
+ 1.761e-06 0
+ 1.7612500000000001e-06 0
+ 1.7615e-06 0
+ 1.7617499999999999e-06 0
+ 1.762e-06 0
+ 1.7622499999999999e-06 0
+ 1.7625000000000001e-06 0
+ 1.76275e-06 0
+ 1.7630000000000001e-06 0
+ 1.76325e-06 0
+ 1.7634999999999999e-06 0
+ 1.7637500000000001e-06 0
+ 1.764e-06 0
+ 1.7642500000000001e-06 0
+ 1.7645e-06 0
+ 1.7647499999999999e-06 0
+ 1.765e-06 0
+ 1.76525e-06 0
+ 1.7655000000000001e-06 0
+ 1.76575e-06 0
+ 1.7659999999999999e-06 0
+ 1.76625e-06 0
+ 1.7664999999999999e-06 0
+ 1.7667500000000001e-06 0
+ 1.767e-06 0
+ 1.7672500000000001e-06 0
+ 1.7675e-06 0
+ 1.7677499999999999e-06 0
+ 1.7680000000000001e-06 0
+ 1.76825e-06 0
+ 1.7685000000000001e-06 0
+ 1.76875e-06 0
+ 1.7689999999999999e-06 0
+ 1.76925e-06 0
+ 1.7695e-06 0
+ 1.7697500000000001e-06 0
+ 1.77e-06 0
+ 1.7702499999999999e-06 0
+ 1.7705e-06 0
+ 1.7707499999999999e-06 0
+ 1.7710000000000001e-06 0
+ 1.77125e-06 0
+ 1.7714999999999999e-06 0
+ 1.77175e-06 0
+ 1.7719999999999999e-06 0
+ 1.7722500000000001e-06 0
+ 1.7725e-06 0
+ 1.7727500000000001e-06 0
+ 1.773e-06 0
+ 1.7732499999999999e-06 0
+ 1.7735e-06 0
+ 1.77375e-06 0
+ 1.7740000000000001e-06 0
+ 1.77425e-06 0
+ 1.7744999999999999e-06 0
+ 1.77475e-06 0
+ 1.7749999999999999e-06 0
+ 1.7752500000000001e-06 0
+ 1.7755e-06 0
+ 1.7757499999999999e-06 0
+ 1.776e-06 0
+ 1.7762499999999999e-06 0
+ 1.7765000000000001e-06 0
+ 1.77675e-06 0
+ 1.7770000000000001e-06 0
+ 1.77725e-06 0
+ 1.7774999999999999e-06 0
+ 1.77775e-06 0
+ 1.778e-06 0
+ 1.7782500000000001e-06 0
+ 1.7785e-06 0
+ 1.7787499999999999e-06 0
+ 1.779e-06 0
+ 1.7792499999999999e-06 0
+ 1.7795000000000001e-06 0
+ 1.77975e-06 0
+ 1.7799999999999999e-06 0
+ 1.78025e-06 0
+ 1.7804999999999999e-06 0
+ 1.7807500000000001e-06 0
+ 1.781e-06 0
+ 1.7812500000000001e-06 0
+ 1.7815e-06 0
+ 1.7817499999999999e-06 0
+ 1.782e-06 0
+ 1.78225e-06 0
+ 1.7825000000000001e-06 0
+ 1.78275e-06 0
+ 1.7829999999999999e-06 0
+ 1.78325e-06 0
+ 1.7834999999999999e-06 0
+ 1.7837500000000001e-06 0
+ 1.784e-06 0
+ 1.7842499999999999e-06 0
+ 1.7845e-06 0
+ 1.7847499999999999e-06 0
+ 1.7850000000000001e-06 0
+ 1.78525e-06 0
+ 1.7855000000000001e-06 0
+ 1.78575e-06 0
+ 1.7859999999999999e-06 0
+ 1.7862500000000001e-06 0
+ 1.7865e-06 0
+ 1.7867500000000001e-06 0
+ 1.787e-06 0
+ 1.7872499999999999e-06 0
+ 1.7875e-06 0
+ 1.78775e-06 0
+ 1.7880000000000001e-06 0
+ 1.78825e-06 0
+ 1.7884999999999999e-06 0
+ 1.78875e-06 0
+ 1.7889999999999999e-06 0
+ 1.7892500000000001e-06 0
+ 1.7895e-06 0
+ 1.7897500000000001e-06 0
+ 1.79e-06 0
+ 1.7902499999999999e-06 0
+ 1.7905000000000001e-06 0
+ 1.79075e-06 0
+ 1.7910000000000001e-06 0
+ 1.79125e-06 0
+ 1.7914999999999999e-06 0
+ 1.79175e-06 0
+ 1.792e-06 0
+ 1.7922500000000001e-06 0
+ 1.7925e-06 0
+ 1.7927499999999999e-06 0
+ 1.793e-06 0
+ 1.7932499999999999e-06 0
+ 1.7935000000000001e-06 0
+ 1.79375e-06 0
+ 1.7940000000000001e-06 0
+ 1.79425e-06 0
+ 1.7944999999999999e-06 0
+ 1.7947500000000001e-06 0
+ 1.795e-06 0
+ 1.7952500000000001e-06 0
+ 1.7955e-06 0
+ 1.7957499999999999e-06 0
+ 1.796e-06 0
+ 1.79625e-06 0
+ 1.7965000000000001e-06 0
+ 1.79675e-06 0
+ 1.7969999999999999e-06 0
+ 1.79725e-06 0
+ 1.7974999999999999e-06 0
+ 1.7977500000000001e-06 0
+ 1.798e-06 0
+ 1.7982500000000001e-06 0
+ 1.7985e-06 0
+ 1.7987499999999999e-06 0
+ 1.7990000000000001e-06 0
+ 1.79925e-06 0
+ 1.7995000000000001e-06 0
+ 1.79975e-06 0
+ 1.7999999999999999e-06 0
+ 1.80025e-06 0
+ 1.8005e-06 0
+ 1.8007500000000001e-06 0
+ 1.801e-06 0
+ 1.8012499999999999e-06 0
+ 1.8015e-06 0
+ 1.8017499999999999e-06 0
+ 1.8020000000000001e-06 0
+ 1.80225e-06 0
+ 1.8024999999999999e-06 0
+ 1.80275e-06 0
+ 1.8029999999999999e-06 0
+ 1.8032500000000001e-06 0
+ 1.8035e-06 0
+ 1.8037500000000001e-06 0
+ 1.804e-06 0
+ 1.8042499999999999e-06 0
+ 1.8045e-06 0
+ 1.80475e-06 0
+ 1.8050000000000001e-06 0
+ 1.80525e-06 0
+ 1.8054999999999999e-06 0
+ 1.80575e-06 0
+ 1.8059999999999999e-06 0
+ 1.8062500000000001e-06 0
+ 1.8065e-06 0
+ 1.8067499999999999e-06 0
+ 1.807e-06 0
+ 1.8072499999999999e-06 0
+ 1.8075000000000001e-06 0
+ 1.80775e-06 0
+ 1.8080000000000001e-06 0
+ 1.80825e-06 0
+ 1.8084999999999999e-06 0
+ 1.80875e-06 0
+ 1.809e-06 0
+ 1.8092500000000001e-06 0
+ 1.8095e-06 0
+ 1.8097499999999999e-06 0
+ 1.81e-06 0
+ 1.8102499999999999e-06 0
+ 1.8105000000000001e-06 0
+ 1.81075e-06 0
+ 1.8109999999999999e-06 0
+ 1.81125e-06 0
+ 1.8114999999999999e-06 0
+ 1.8117500000000001e-06 0
+ 1.812e-06 0
+ 1.8122500000000001e-06 0
+ 1.8125e-06 0
+ 1.8127499999999999e-06 0
+ 1.813e-06 0
+ 1.81325e-06 0
+ 1.8135000000000001e-06 0
+ 1.81375e-06 0
+ 1.8139999999999999e-06 0
+ 1.81425e-06 0
+ 1.8144999999999999e-06 0
+ 1.8147500000000001e-06 0
+ 1.815e-06 0
+ 1.8152499999999999e-06 0
+ 1.8155e-06 0
+ 1.8157499999999999e-06 0
+ 1.8160000000000001e-06 0
+ 1.81625e-06 0
+ 1.8165000000000001e-06 0
+ 1.81675e-06 0
+ 1.8169999999999999e-06 0
+ 1.81725e-06 0
+ 1.8175e-06 0
+ 1.8177500000000001e-06 0
+ 1.818e-06 0
+ 1.8182499999999999e-06 0
+ 1.8185e-06 0
+ 1.81875e-06 0
+ 1.8190000000000001e-06 0
+ 1.81925e-06 0
+ 1.8194999999999999e-06 0
+ 1.81975e-06 0
+ 1.8199999999999999e-06 0
+ 1.8202500000000001e-06 0
+ 1.8205e-06 0
+ 1.8207500000000001e-06 0
+ 1.821e-06 0
+ 1.8212499999999999e-06 0
+ 1.8215000000000001e-06 0
+ 1.82175e-06 0
+ 1.8220000000000001e-06 0
+ 1.82225e-06 0
+ 1.8224999999999999e-06 0
+ 1.82275e-06 0
+ 1.823e-06 0
+ 1.8232500000000001e-06 0
+ 1.8235e-06 0
+ 1.8237499999999999e-06 0
+ 1.824e-06 0
+ 1.8242499999999999e-06 0
+ 1.8245000000000001e-06 0
+ 1.82475e-06 0
+ 1.8250000000000001e-06 0
+ 1.82525e-06 0
+ 1.8254999999999999e-06 0
+ 1.8257500000000001e-06 0
+ 1.826e-06 0
+ 1.8262500000000001e-06 0
+ 1.8265e-06 0
+ 1.8267499999999999e-06 0
+ 1.827e-06 0
+ 1.82725e-06 0
+ 1.8275000000000001e-06 0
+ 1.82775e-06 0
+ 1.8279999999999999e-06 0
+ 1.82825e-06 0
+ 1.8284999999999999e-06 0
+ 1.8287500000000001e-06 0
+ 1.829e-06 0
+ 1.8292500000000001e-06 0
+ 1.8295e-06 0
+ 1.8297499999999999e-06 0
+ 1.8300000000000001e-06 0
+ 1.83025e-06 0
+ 1.8305000000000001e-06 0
+ 1.83075e-06 0
+ 1.8309999999999999e-06 0
+ 1.83125e-06 0
+ 1.8315e-06 0
+ 1.8317500000000001e-06 0
+ 1.832e-06 0
+ 1.8322499999999999e-06 0
+ 1.8325e-06 0
+ 1.8327499999999999e-06 0
+ 1.8330000000000001e-06 0
+ 1.83325e-06 0
+ 1.8334999999999999e-06 0
+ 1.83375e-06 0
+ 1.8339999999999999e-06 0
+ 1.8342500000000001e-06 0
+ 1.8345e-06 0
+ 1.8347500000000001e-06 0
+ 1.835e-06 0
+ 1.8352499999999999e-06 0
+ 1.8355e-06 0
+ 1.83575e-06 0
+ 1.8360000000000001e-06 0
+ 1.83625e-06 0
+ 1.8364999999999999e-06 0
+ 1.83675e-06 0
+ 1.8369999999999999e-06 0
+ 1.8372500000000001e-06 0
+ 1.8375e-06 0
+ 1.8377499999999999e-06 0
+ 1.838e-06 0
+ 1.8382499999999999e-06 0
+ 1.8385000000000001e-06 0
+ 1.83875e-06 0
+ 1.8390000000000001e-06 0
+ 1.83925e-06 0
+ 1.8394999999999999e-06 0
+ 1.83975e-06 0
+ 1.84e-06 0
+ 1.8402500000000001e-06 0
+ 1.8405e-06 0
+ 1.8407499999999999e-06 0
+ 1.841e-06 0
+ 1.8412499999999999e-06 0
+ 1.8415000000000001e-06 0
+ 1.84175e-06 0
+ 1.8419999999999999e-06 0
+ 1.84225e-06 0
+ 1.8424999999999999e-06 0
+ 1.8427500000000001e-06 0
+ 1.843e-06 0
+ 1.8432500000000001e-06 0
+ 1.8435e-06 0
+ 1.8437499999999999e-06 0
+ 1.844e-06 0
+ 1.84425e-06 0
+ 1.8445000000000001e-06 0
+ 1.84475e-06 0
+ 1.8449999999999999e-06 0
+ 1.84525e-06 0
+ 1.8454999999999999e-06 0
+ 1.8457500000000001e-06 0
+ 1.846e-06 0
+ 1.8462499999999999e-06 0
+ 1.8465e-06 0
+ 1.8467499999999999e-06 0
+ 1.8470000000000001e-06 0
+ 1.84725e-06 0
+ 1.8475000000000001e-06 0
+ 1.84775e-06 0
+ 1.8479999999999999e-06 0
+ 1.84825e-06 0
+ 1.8485e-06 0
+ 1.8487500000000001e-06 0
+ 1.849e-06 0
+ 1.8492499999999999e-06 0
+ 1.8495e-06 0
+ 1.84975e-06 0
+ 1.8500000000000001e-06 0
+ 1.85025e-06 0
+ 1.8504999999999999e-06 0
+ 1.85075e-06 0
+ 1.8509999999999999e-06 0
+ 1.8512500000000001e-06 0
+ 1.8515e-06 0
+ 1.8517500000000001e-06 0
+ 1.852e-06 0
+ 1.8522499999999999e-06 0
+ 1.8525000000000001e-06 0
+ 1.85275e-06 0
+ 1.8530000000000001e-06 0
+ 1.85325e-06 0
+ 1.8534999999999999e-06 0
+ 1.85375e-06 0
+ 1.854e-06 0
+ 1.8542500000000001e-06 0
+ 1.8545e-06 0
+ 1.8547499999999999e-06 0
+ 1.855e-06 0
+ 1.8552499999999999e-06 0
+ 1.8555000000000001e-06 0
+ 1.85575e-06 0
+ 1.8560000000000001e-06 0
+ 1.85625e-06 0
+ 1.8564999999999999e-06 0
+ 1.8567500000000001e-06 0
+ 1.857e-06 0
+ 1.8572500000000001e-06 0
+ 1.8575e-06 0
+ 1.8577499999999999e-06 0
+ 1.858e-06 0
+ 1.85825e-06 0
+ 1.8585000000000001e-06 0
+ 1.85875e-06 0
+ 1.8589999999999999e-06 0
+ 1.85925e-06 0
+ 1.8594999999999999e-06 0
+ 1.8597500000000001e-06 0
+ 1.86e-06 0
+ 1.8602500000000001e-06 0
+ 1.8605e-06 0
+ 1.8607499999999999e-06 0
+ 1.8610000000000001e-06 0
+ 1.86125e-06 0
+ 1.8615000000000001e-06 0
+ 1.86175e-06 0
+ 1.8619999999999999e-06 0
+ 1.86225e-06 0
+ 1.8625e-06 0
+ 1.8627500000000001e-06 0
+ 1.863e-06 0
+ 1.8632499999999999e-06 0
+ 1.8635e-06 0
+ 1.8637499999999999e-06 0
+ 1.8640000000000001e-06 0
+ 1.86425e-06 0
+ 1.8645000000000001e-06 0
+ 1.86475e-06 0
+ 1.8649999999999999e-06 0
+ 1.8652500000000001e-06 0
+ 1.8655e-06 0
+ 1.8657500000000001e-06 0
+ 1.866e-06 0
+ 1.8662499999999999e-06 0
+ 1.8665e-06 0
+ 1.86675e-06 0
+ 1.8670000000000001e-06 0
+ 1.86725e-06 0
+ 1.8674999999999999e-06 0
+ 1.86775e-06 0
+ 1.8679999999999999e-06 0
+ 1.8682500000000001e-06 0
+ 1.8685e-06 0
+ 1.8687499999999999e-06 0
+ 1.869e-06 0
+ 1.8692499999999999e-06 0
+ 1.8695000000000001e-06 0
+ 1.86975e-06 0
+ 1.8700000000000001e-06 0
+ 1.87025e-06 0
+ 1.8704999999999999e-06 0
+ 1.87075e-06 0
+ 1.871e-06 0
+ 1.8712500000000001e-06 0
+ 1.8715e-06 0
+ 1.8717499999999999e-06 0
+ 1.872e-06 0
+ 1.8722499999999999e-06 0
+ 1.8725000000000001e-06 0
+ 1.87275e-06 0
+ 1.8729999999999999e-06 0
+ 1.87325e-06 0
+ 1.8734999999999999e-06 0
+ 1.8737500000000001e-06 0
+ 1.874e-06 0
+ 1.8742500000000001e-06 0
+ 1.8745e-06 0
+ 1.8747499999999999e-06 0
+ 1.875e-06 0
+ 1.87525e-06 0
+ 1.8755000000000001e-06 0
+ 1.87575e-06 0
+ 1.8759999999999999e-06 0
+ 1.87625e-06 0
+ 1.8764999999999999e-06 0
+ 1.8767500000000001e-06 0
+ 1.877e-06 0
+ 1.8772499999999999e-06 0
+ 1.8775e-06 0
+ 1.8777499999999999e-06 0
+ 1.8780000000000001e-06 0
+ 1.87825e-06 0
+ 1.8785000000000001e-06 0
+ 1.87875e-06 0
+ 1.8789999999999999e-06 0
+ 1.87925e-06 0
+ 1.8795e-06 0
+ 1.8797500000000001e-06 0
+ 1.88e-06 0
+ 1.8802499999999999e-06 0
+ 1.8805e-06 0
+ 1.88075e-06 0
+ 1.8810000000000001e-06 0
+ 1.88125e-06 0
+ 1.8814999999999999e-06 0
+ 1.88175e-06 0
+ 1.8819999999999999e-06 0
+ 1.8822500000000001e-06 0
+ 1.8825e-06 0
+ 1.8827500000000001e-06 0
+ 1.883e-06 0
+ 1.8832499999999999e-06 0
+ 1.8835000000000001e-06 0
+ 1.88375e-06 0
+ 1.8840000000000001e-06 0
+ 1.88425e-06 0
+ 1.8844999999999999e-06 0
+ 1.88475e-06 0
+ 1.885e-06 0
+ 1.8852500000000001e-06 0
+ 1.8855e-06 0
+ 1.8857499999999999e-06 0
+ 1.886e-06 0
+ 1.8862499999999999e-06 0
+ 1.8865000000000001e-06 0
+ 1.88675e-06 0
+ 1.8870000000000001e-06 0
+ 1.88725e-06 0
+ 1.8874999999999999e-06 0
+ 1.8877500000000001e-06 0
+ 1.888e-06 0
+ 1.8882500000000001e-06 0
+ 1.8885e-06 0
+ 1.8887499999999999e-06 0
+ 1.889e-06 0
+ 1.88925e-06 0
+ 1.8895000000000001e-06 0
+ 1.88975e-06 0
+ 1.8899999999999999e-06 0
+ 1.89025e-06 0
+ 1.8904999999999999e-06 0
+ 1.8907500000000001e-06 0
+ 1.891e-06 0
+ 1.8912500000000001e-06 0
+ 1.8915e-06 0
+ 1.8917499999999999e-06 0
+ 1.8920000000000001e-06 0
+ 1.89225e-06 0
+ 1.8925000000000001e-06 0
+ 1.89275e-06 0
+ 1.8929999999999999e-06 0
+ 1.89325e-06 0
+ 1.8935e-06 0
+ 1.8937500000000001e-06 0
+ 1.894e-06 0
+ 1.8942499999999999e-06 0
+ 1.8945e-06 0
+ 1.8947499999999999e-06 0
+ 1.8950000000000001e-06 0
+ 1.89525e-06 0
+ 1.8955000000000001e-06 0
+ 1.89575e-06 0
+ 1.8959999999999999e-06 0
+ 1.8962500000000001e-06 0
+ 1.8965e-06 0
+ 1.8967500000000001e-06 0
+ 1.897e-06 0
+ 1.8972499999999999e-06 0
+ 1.8975e-06 0
+ 1.89775e-06 0
+ 1.8980000000000001e-06 0
+ 1.89825e-06 0
+ 1.8984999999999999e-06 0
+ 1.89875e-06 0
+ 1.8989999999999999e-06 0
+ 1.8992500000000001e-06 0
+ 1.8995e-06 0
+ 1.8997499999999999e-06 0
+ 1.9e-06 0
+ 1.9002499999999999e-06 0
+ 1.9005000000000001e-06 0
+ 1.90075e-06 0
+ 1.9010000000000001e-06 0
+ 1.90125e-06 0
+ 1.9014999999999999e-06 0
+ 1.90175e-06 0
+ 1.902e-06 0
+ 1.9022500000000001e-06 0
+ 1.9025e-06 0
+ 1.9027499999999999e-06 0
+ 1.903e-06 0
+ 1.9032499999999999e-06 0
+ 1.9035000000000001e-06 0
+ 1.90375e-06 0
+ 1.9039999999999999e-06 0
+ 1.90425e-06 0
+ 1.9044999999999999e-06 0
+ 1.9047500000000001e-06 0
+ 1.905e-06 0
+ 1.9052500000000001e-06 0
+ 1.9055e-06 0
+ 1.9057499999999999e-06 0
+ 1.906e-06 0
+ 1.90625e-06 0
+ 1.9065000000000001e-06 0
+ 1.90675e-06 0
+ 1.9069999999999999e-06 0
+ 1.90725e-06 0
+ 1.9074999999999999e-06 0
+ 1.9077500000000001e-06 0
+ 1.9080000000000002e-06 0
+ 1.9082499999999999e-06 0
+ 1.9085e-06 0
+ 1.9087500000000001e-06 0
+ 1.9089999999999998e-06 0
+ 1.90925e-06 0
+ 1.9095000000000001e-06 0
+ 1.9097499999999998e-06 0
+ 1.9099999999999999e-06 0
+ 1.91025e-06 0
+ 1.9105000000000002e-06 0
+ 1.9107499999999999e-06 0
+ 1.911e-06 0
+ 1.9112500000000001e-06 0
+ 1.9114999999999998e-06 0
+ 1.9117499999999999e-06 0
+ 1.9120000000000001e-06 0
+ 1.9122500000000002e-06 0
+ 1.9124999999999999e-06 0
+ 1.91275e-06 0
+ 1.9130000000000001e-06 0
+ 1.9132499999999999e-06 0
+ 1.9135e-06 0
+ 1.9137500000000001e-06 0
+ 1.9139999999999998e-06 0
+ 1.9142499999999999e-06 0
+ 1.9145000000000001e-06 0
+ 1.9147500000000002e-06 0
+ 1.9149999999999999e-06 0
+ 1.91525e-06 0
+ 1.9155000000000001e-06 0
+ 1.9157499999999998e-06 0
+ 1.916e-06 0
+ 1.9162500000000001e-06 0
+ 1.9165000000000002e-06 0
+ 1.9167499999999999e-06 0
+ 1.917e-06 0
+ 1.9172500000000002e-06 0
+ 1.9174999999999999e-06 0
+ 1.91775e-06 0
+ 1.9180000000000001e-06 0
+ 1.9182499999999998e-06 0
+ 1.9184999999999999e-06 0
+ 1.9187500000000001e-06 0
+ 1.9190000000000002e-06 0
+ 1.9192499999999999e-06 0
+ 1.9195e-06 0
+ 1.9197500000000001e-06 0
+ 1.9199999999999998e-06 0
+ 1.92025e-06 0
+ 1.9205000000000001e-06 0
+ 1.9207500000000002e-06 0
+ 1.9209999999999999e-06 0
+ 1.92125e-06 0
+ 1.9215000000000002e-06 0
+ 1.9217499999999999e-06 0
+ 1.922e-06 0
+ 1.9222500000000001e-06 0
+ 1.9224999999999998e-06 0
+ 1.9227499999999999e-06 0
+ 1.9230000000000001e-06 0
+ 1.9232500000000002e-06 0
+ 1.9234999999999999e-06 0
+ 1.92375e-06 0
+ 1.9240000000000001e-06 0
+ 1.9242499999999998e-06 0
+ 1.9245e-06 0
+ 1.9247500000000001e-06 0
+ 1.9250000000000002e-06 0
+ 1.9252499999999999e-06 0
+ 1.9255e-06 0
+ 1.9257500000000002e-06 0
+ 1.9259999999999999e-06 0
+ 1.92625e-06 0
+ 1.9265000000000001e-06 0
+ 1.9267499999999998e-06 0
+ 1.9269999999999999e-06 0
+ 1.9272500000000001e-06 0
+ 1.9275000000000002e-06 0
+ 1.9277499999999999e-06 0
+ 1.928e-06 0
+ 1.9282500000000001e-06 0
+ 1.9284999999999998e-06 0
+ 1.92875e-06 0
+ 1.9290000000000001e-06 0
+ 1.9292500000000002e-06 0
+ 1.9294999999999999e-06 0
+ 1.92975e-06 0
+ 1.9300000000000002e-06 0
+ 1.9302499999999999e-06 0
+ 1.9305e-06 0
+ 1.9307500000000001e-06 0
+ 1.9309999999999998e-06 0
+ 1.9312499999999999e-06 0
+ 1.9315000000000001e-06 0
+ 1.9317500000000002e-06 0
+ 1.9319999999999999e-06 0
+ 1.93225e-06 0
+ 1.9325000000000001e-06 0
+ 1.9327499999999998e-06 0
+ 1.933e-06 0
+ 1.9332500000000001e-06 0
+ 1.9335000000000002e-06 0
+ 1.9337499999999999e-06 0
+ 1.934e-06 0
+ 1.9342500000000002e-06 0
+ 1.9344999999999999e-06 0
+ 1.93475e-06 0
+ 1.9350000000000001e-06 0
+ 1.9352499999999998e-06 0
+ 1.9354999999999999e-06 0
+ 1.9357500000000001e-06 0
+ 1.9360000000000002e-06 0
+ 1.9362499999999999e-06 0
+ 1.9365e-06 0
+ 1.9367500000000001e-06 0
+ 1.9369999999999998e-06 0
+ 1.93725e-06 0
+ 1.9375000000000001e-06 0
+ 1.9377500000000002e-06 0
+ 1.9379999999999999e-06 0
+ 1.93825e-06 0
+ 1.9385000000000002e-06 0
+ 1.9387499999999999e-06 0
+ 1.939e-06 0
+ 1.9392500000000001e-06 0
+ 1.9394999999999998e-06 0
+ 1.9397499999999999e-06 0
+ 1.9400000000000001e-06 0
+ 1.9402500000000002e-06 0
+ 1.9404999999999999e-06 0
+ 1.94075e-06 0
+ 1.9410000000000001e-06 0
+ 1.9412499999999998e-06 0
+ 1.9415e-06 0
+ 1.9417500000000001e-06 0
+ 1.9420000000000002e-06 0
+ 1.9422499999999999e-06 0
+ 1.9425e-06 0
+ 1.9427500000000002e-06 0
+ 1.9429999999999999e-06 0
+ 1.94325e-06 0
+ 1.9435000000000001e-06 0
+ 1.9437499999999998e-06 0
+ 1.9439999999999999e-06 0
+ 1.9442500000000001e-06 0
+ 1.9445000000000002e-06 0
+ 1.9447499999999999e-06 0
+ 1.945e-06 0
+ 1.9452500000000001e-06 0
+ 1.9454999999999998e-06 0
+ 1.94575e-06 0
+ 1.9460000000000001e-06 0
+ 1.9462499999999998e-06 0
+ 1.9464999999999999e-06 0
+ 1.94675e-06 0
+ 1.9470000000000002e-06 0
+ 1.9472499999999999e-06 0
+ 1.9475e-06 0
+ 1.9477500000000001e-06 0
+ 1.9479999999999998e-06 0
+ 1.9482499999999999e-06 0
+ 1.9485000000000001e-06 0
+ 1.9487500000000002e-06 0
+ 1.9489999999999999e-06 0
+ 1.94925e-06 0
+ 1.9495000000000001e-06 0
+ 1.9497499999999998e-06 0
+ 1.95e-06 0
+ 1.9502500000000001e-06 0
+ 1.9504999999999998e-06 0
+ 1.9507499999999999e-06 0
+ 1.951e-06 0
+ 1.9512500000000002e-06 0
+ 1.9514999999999999e-06 0
+ 1.95175e-06 0
+ 1.9520000000000001e-06 0
+ 1.9522499999999998e-06 0
+ 1.9524999999999999e-06 0
+ 1.9527500000000001e-06 0
+ 1.9530000000000002e-06 0
+ 1.9532499999999999e-06 0
+ 1.9535e-06 0
+ 1.9537500000000001e-06 0
+ 1.9539999999999998e-06 0
+ 1.95425e-06 0
+ 1.9545000000000001e-06 0
+ 1.9547499999999998e-06 0
+ 1.9549999999999999e-06 0
+ 1.95525e-06 0
+ 1.9555000000000002e-06 0
+ 1.9557499999999999e-06 0
+ 1.956e-06 0
+ 1.9562500000000001e-06 0
+ 1.9564999999999998e-06 0
+ 1.9567499999999999e-06 0
+ 1.9570000000000001e-06 0
+ 1.9572500000000002e-06 0
+ 1.9574999999999999e-06 0
+ 1.95775e-06 0
+ 1.9580000000000001e-06 0
+ 1.9582499999999998e-06 0
+ 1.9585e-06 0
+ 1.9587500000000001e-06 0
+ 1.9589999999999998e-06 0
+ 1.9592499999999999e-06 0
+ 1.9595e-06 0
+ 1.9597500000000002e-06 0
+ 1.9599999999999999e-06 0
+ 1.96025e-06 0
+ 1.9605000000000001e-06 0
+ 1.9607499999999998e-06 0
+ 1.9609999999999999e-06 0
+ 1.9612500000000001e-06 0
+ 1.9615000000000002e-06 0
+ 1.9617499999999999e-06 0
+ 1.962e-06 0
+ 1.9622500000000001e-06 0
+ 1.9624999999999998e-06 0
+ 1.96275e-06 0
+ 1.9630000000000001e-06 0
+ 1.9632499999999998e-06 0
+ 1.9634999999999999e-06 0
+ 1.96375e-06 0
+ 1.9640000000000002e-06 0
+ 1.9642499999999999e-06 0
+ 1.9645e-06 0
+ 1.9647500000000001e-06 0
+ 1.9649999999999998e-06 0
+ 1.9652499999999999e-06 0
+ 1.9655000000000001e-06 0
+ 1.9657500000000002e-06 0
+ 1.9659999999999999e-06 0
+ 1.96625e-06 0
+ 1.9665000000000001e-06 0
+ 1.9667499999999998e-06 0
+ 1.967e-06 0
+ 1.9672500000000001e-06 0
+ 1.9674999999999998e-06 0
+ 1.9677499999999999e-06 0
+ 1.968e-06 0
+ 1.9682500000000002e-06 0
+ 1.9684999999999999e-06 0
+ 1.96875e-06 0
+ 1.9690000000000001e-06 0
+ 1.9692499999999998e-06 0
+ 1.9694999999999999e-06 0
+ 1.9697500000000001e-06 0
+ 1.9700000000000002e-06 0
+ 1.9702499999999999e-06 0
+ 1.9705e-06 0
+ 1.9707500000000001e-06 0
+ 1.9709999999999998e-06 0
+ 1.97125e-06 0
+ 1.9715000000000001e-06 0
+ 1.9717499999999998e-06 0
+ 1.9719999999999999e-06 0
+ 1.97225e-06 0
+ 1.9725000000000002e-06 0
+ 1.9727499999999999e-06 0
+ 1.973e-06 0
+ 1.9732500000000001e-06 0
+ 1.9734999999999998e-06 0
+ 1.9737499999999999e-06 0
+ 1.9740000000000001e-06 0
+ 1.9742500000000002e-06 0
+ 1.9744999999999999e-06 0
+ 1.97475e-06 0
+ 1.9750000000000001e-06 0
+ 1.9752499999999999e-06 0
+ 1.9755e-06 0
+ 1.9757500000000001e-06 0
+ 1.9759999999999998e-06 0
+ 1.9762499999999999e-06 0
+ 1.9765e-06 0
+ 1.9767500000000002e-06 0
+ 1.9769999999999999e-06 0
+ 1.97725e-06 0
+ 1.9775000000000001e-06 0
+ 1.9777499999999998e-06 0
+ 1.978e-06 0
+ 1.9782500000000001e-06 0
+ 1.9785000000000002e-06 0
+ 1.9787499999999999e-06 0
+ 1.979e-06 0
+ 1.9792500000000002e-06 0
+ 1.9794999999999999e-06 0
+ 1.97975e-06 0
+ 1.9800000000000001e-06 0
+ 1.9802499999999998e-06 0
+ 1.9804999999999999e-06 0
+ 1.9807500000000001e-06 0
+ 1.9810000000000002e-06 0
+ 1.9812499999999999e-06 0
+ 1.9815e-06 0
+ 1.9817500000000001e-06 0
+ 1.9819999999999998e-06 0
+ 1.98225e-06 0
+ 1.9825000000000001e-06 0
+ 1.9827500000000002e-06 0
+ 1.9829999999999999e-06 0
+ 1.98325e-06 0
+ 1.9835000000000002e-06 0
+ 1.9837499999999999e-06 0
+ 1.984e-06 0
+ 1.9842500000000001e-06 0
+ 1.9844999999999998e-06 0
+ 1.9847499999999999e-06 0
+ 1.9850000000000001e-06 0
+ 1.9852500000000002e-06 0
+ 1.9854999999999999e-06 0
+ 1.98575e-06 0
+ 1.9860000000000001e-06 0
+ 1.9862499999999998e-06 0
+ 1.9865e-06 0
+ 1.9867500000000001e-06 0
+ 1.9870000000000002e-06 0
+ 1.9872499999999999e-06 0
+ 1.9875e-06 0
+ 1.9877500000000002e-06 0
+ 1.9879999999999999e-06 0
+ 1.98825e-06 0
+ 1.9885000000000001e-06 0
+ 1.9887499999999998e-06 0
+ 1.9889999999999999e-06 0
+ 1.9892500000000001e-06 0
+ 1.9895000000000002e-06 0
+ 1.9897499999999999e-06 0
+ 1.99e-06 0
+ 1.9902500000000001e-06 0
+ 1.9904999999999998e-06 0
+ 1.99075e-06 0
+ 1.9910000000000001e-06 0
+ 1.9912500000000002e-06 0
+ 1.9914999999999999e-06 0
+ 1.99175e-06 0
+ 1.9920000000000002e-06 0
+ 1.9922499999999999e-06 0
+ 1.9925e-06 0
+ 1.9927500000000001e-06 0
+ 1.9929999999999998e-06 0
+ 1.9932499999999999e-06 0
+ 1.9935000000000001e-06 0
+ 1.9937500000000002e-06 0
+ 1.9939999999999999e-06 0
+ 1.99425e-06 0
+ 1.9945000000000001e-06 0
+ 1.9947499999999998e-06 0
+ 1.995e-06 0
+ 1.9952500000000001e-06 0
+ 1.9955000000000002e-06 0
+ 1.9957499999999999e-06 0
+ 1.996e-06 0
+ 1.9962500000000002e-06 0
+ 1.9964999999999999e-06 0
+ 1.99675e-06 0
+ 1.9970000000000001e-06 0
+ 1.9972499999999998e-06 0
+ 1.9974999999999999e-06 0
+ 1.9977500000000001e-06 0
+ 1.9980000000000002e-06 0
+ 1.9982499999999999e-06 0
+ 1.9985e-06 0
+ 1.9987500000000001e-06 0
+ 1.9989999999999998e-06 0
+ 1.99925e-06 0
+ 1.9995000000000001e-06 0
+ 1.9997500000000002e-06 0
+ 1.9999999999999999e-06 0
+ 0.00013821875 0
+ 0.00013822031250000001 0
+ 0.000138221875 0
+ 0.00013822343749999999 0
+ 0.00013822362400000001 0
+ 0.00013822500000000001 0
+ 0.0001382265625 0
+ 0.00013822812499999999 0
+ 0.00013822968750000001 0
+ 0.00013823125 0
+ 0.00013823281249999999 0
+ 0.00013823437500000001 0
+ 0.0001382359375 0
+ 0.00013823749999999999 0
+ 0.00013823906250000001 0
+ 0.000138240625 0
+ 0.00013824218749999999 0
+ 0.00013824375000000001 0
+ 0.0001382453125 0
+ 0.00013824687499999999 0
+ 0.00013824795299999999 0
+ 0.00013824834200000001 0
+ 0.00013824843750000001 0
+ 0.00013824853200000001 0
+ 0.00013824859799999999 0
+ 0.00013825 0
+ 0.00013825156249999999 0
+ 0.00013825312500000001 0
+ 0.0001382546875 0
+ 0.00013825624999999999 0
+ 0.00013825781250000001 0
+ 0.000138259375 0
+ 0.00013826093749999999 0
+ 0.00013826250000000001 0
+ 0.0001382640625 0
+ 0.00013826562499999999 0
+ 0.00013826718750000001 0
+ 0.00013826875 0
+ 0.00013827031249999999 0
+ 0.00013827187500000001 0
+ 0.0001382734375 0
+ 0.00013827499999999999 0
+ 0.0001382765625 0
+ 0.000138278125 0
+ 0.00013827968750000001 0
+ 0.00013828125 0
+ 0.00013828281249999999 0
+ 0.00013828437500000001 0
+ 0.0001382859375 0
+ 0.00013828749999999999 0
+ 0.00013828906250000001 0
+ 0.000138290625 0
+ 0.00013829218749999999 0
+ 0.00013829375000000001 0
+ 0.0001382953125 0
+ 0.00013829687499999999 0
+ 0.00013829843750000001 0
+ 0.0001383 0
+ 0.00013830156249999999 0
+ 0.00013830312500000001 0
+ 0.0001383046875 0
+ 0.00013830624999999999 0
+ 0.00013830781250000001 0
+ 0.000138309375 0
+ 0.00013831093749999999 0
+ 0.00013831250000000001 0
+ 0.0001383140625 0
+ 0.00013831562499999999 0
+ 0.00013831718750000001 0
+ 0.00013831727199999999 0
+ 0.00013831875 0
+ 0.00013832031249999999 0
+ 0.00013832187500000001 0
+ 0.0001383234375 0
+ 0.00013832499999999999 0
+ 0.00013832656250000001 0
+ 0.000138328125 0
+ 0.00013832968749999999 0
+ 0.00013833125 0
+ 0.0001383328125 0
+ 0.00013833437500000001 0
+ 0.0001383359375 0
+ 0.00013833749999999999 0
+ 0.00013833906250000001 0
+ 0.000138340625 0
+ 0.00013834218749999999 0
+ 0.00013834375000000001 0
+ 0.0001383453125 0
+ 0.00013834687499999999 0
+ 0.00013834843750000001 0
+ 0.00013835 0
+ 0.00013835156249999999 0
+ 0.00013835312500000001 0
+ 0.0001383546875 0
+ 0.00013835624999999999 0
+ 0.00013835781250000001 0
+ 0.000138359375 0
+ 0.00013836093749999999 0
+ 0.00013836250000000001 0
+ 0.0001383640625 0
+ 0.00013836562499999999 0
+ 0.00013836718750000001 0
+ 0.00013836875 0
+ 0.00013837031249999999 0
+ 0.00013837187500000001 0
+ 0.0001383734375 0
+ 0.00013837499999999999 0
+ 0.00013837656250000001 0
+ 0.000138378125 0
+ 0.00013837968749999999 0
+ 0.00013838125000000001 0
+ 0.0001383828125 0
+ 0.00013838437499999999 0
+ 0.00013838593750000001 0
+ 0.0001383875 0
+ 0.00013838906249999999 0
+ 0.000138390625 0
+ 0.0001383921875 0
+ 0.00013839375000000001 0
+ 0.0001383953125 0
+ 0.00013839687499999999 0
+ 0.00013839843750000001 0
+ 0.0001384 0
+ 0.00013840156249999999 0
+ 0.00013840312500000001 0
+ 0.0001384046875 0
+ 0.00013840624999999999 0
+ 0.00013840781250000001 0
+ 0.000138409375 0
+ 0.00013841093749999999 0
+ 0.00013841250000000001 0
+ 0.0001384140625 0
+ 0.00013841562499999999 0
+ 0.00013841718750000001 0
+ 0.00013846235599999999 0
+ 0.0010011765625 0
+ 0.0010011781250000001 0
+ 0.0010011796874999999 0
+ 0.0010011812499999999 0
+ 0.0010011828125 0
+ 0.001001184375 0
+ 0.0010011859375000001 0
+ 0.0010011874999999999 0
+ 0.0010011890625 0
+ 0.001001190625 0
+ 0.0010011921875 0
+ 0.0010011937500000001 0
+ 0.0010011953124999999 0
+ 0.001001196875 0
+ 0.0010011984375 0
+ 0.0010012 0
+ 0.0010012015625000001 0
+ 0.0010012031249999999 0
+ 0.0010012046875 0
+ 0.00100120625 0
+ 0.0010012078125000001 0
+ 0.0010012093750000001 0
+ 0.0010012109374999999 0
+ 0.0010012125 0
+ 0.0010012140625 0
+ 0.0010012156250000001 0
+ 0.0010012171874999999 0
+ 0.0010012187499999999 0
+ 0.0010012203125 0
+ 0.001001221875 0
+ 0.0010012234375000001 0
+ 0.0010012249999999999 0
+ 0.0010012265624999999 0
+ 0.001001228125 0
+ 0.0010012296875 0
+ 0.0010012312500000001 0
+ 0.0010012328124999999 0
+ 0.001001234375 0
+ 0.0010012359375 0
+ 0.0010012375 0
+ 0.0010012390625000001 0
+ 0.0010012406249999999 0
+ 0.0010012421875 0
+ 0.00100124375 0
+ 0.0010012453125000001 0
+ 0.0010012468750000001 0
+ 0.0010012484374999999 0
+ 0.00100125 0
+ 0.0010012515625 0
+ 0.0010012531250000001 0
+ 0.0010012546875000001 0
+ 0.0010012562499999999 0
+ 0.0010012578125 0
+ 0.001001259375 0
+ 0.0010012609375000001 0
+ 0.0010012624999999999 0
+ 0.0010012640624999999 0
+ 0.001001265625 0
+ 0.0010012671875 0
+ 0.0010012687500000001 0
+ 0.0010012703124999999 0
+ 0.0010012718749999999 0
+ 0.0010012734375 0
+ 0.001001275 0
+ 0.0010012765625000001 0
+ 0.0010012781249999999 0
+ 0.0010012796875 0
+ 0.00100128125 0
+ 0.0010012828125 0
+ 0.0010012843750000001 0
+ 0.0010012859374999999 0
+ 0.0010012875 0
+ 0.0010012890625 0
+ 0.0010012897010000001 0
+ 0.0010012906250000001 0
+ 0.0010012921875000001 0
+ 0.0010012937499999999 0
+ 0.0010012953125 0
+ 0.00100129638 0
+ 0.001001296875 0
+ 0.0010012984375000001 0
+ 0.0010013000000000001 0
+ 0.0010013015624999999 0
+ 0.001001303125 0
+ 0.0010013046875 0
+ 0.0010013062500000001 0
+ 0.0010013078124999999 0
+ 0.0010013093749999999 0
+ 0.0010013109375 0
+ 0.0010013125 0
+ 0.0010013140625000001 0
+ 0.0010013156249999999 0
+ 0.0010013171875 0
+ 0.00100131875 0
+ 0.0010013203125 0
+ 0.0010013218750000001 0
+ 0.0010013234374999999 0
+ 0.001001325 0
+ 0.0010013265625 0
+ 0.001001328125 0
+ 0.0010013296875000001 0
+ 0.0010013312499999999 0
+ 0.0010013328125 0
+ 0.001001334375 0
+ 0.0010013359375000001 0
+ 0.0010013375000000001 0
+ 0.0010013390624999999 0
+ 0.001001340625 0
+ 0.0010013421875 0
+ 0.0010013437500000001 0
+ 0.0010013453124999999 0
+ 0.0010013468749999999 0
+ 0.0010013484375 0
+ 0.00100135 0
+ 0.0010013515625000001 0
+ 0.0010013531249999999 0
+ 0.0010013546874999999 0
+ 0.00100135625 0
+ 0.0010013578125 0
+ 0.0010013593750000001 0
+ 0.0010013609374999999 0
+ 0.0010013625 0
+ 0.0010013640625 0
+ 0.001001365625 0
+ 0.0010013671875000001 0
+ 0.0010013687499999999 0
+ 0.0010013703125 0
+ 0.001001371875 0
+ 0.0010013734375 0
+ 0.0010013750000000001 0
+ 0.0010013765624999999 0
+ 0.001001378125 0
+ 0.0010013796875 0
+ 0.0010013812500000001 0
+ 0.0010013828125000001 0
+ 0.0010013843749999999 0
+ 0.0010013859375 0
+ 0.0010013875 0
+ 0.0010013890625000001 0
+ 0.0010013906249999999 0
+ 0.0010013921874999999 0
+ 0.00100139375 0
+ 0.0010013953125 0
+ 0.0010013968750000001 0
+ 0.0010013984374999999 0
+ 0.0010013999999999999 0
+ 0.0010014015625 0
+ 0.001001403125 0
+ 0.0010014046875000001 0
+ 0.0010014062499999999 0
+ 0.0010014078125 0
+ 0.001001409375 0
+ 0.0010014109375 0
+ 0.0010014125000000001 0
+ 0.0010014140624999999 0
+ 0.001001415625 0
+ 0.0010014171875 0
+ 0.0010014187500000001 0
+ 0.0010014203125000001 0
+ 0.0010014218749999999 0
+ 0.0010014234375 0
+ 0.001001425 0
+ 0.0010014265625000001 0
+ 0.0010014281250000001 0
+ 0.0010014296874999999 0
+ 0.00100143125 0
+ 0.0010014328125 0
+ 0.0010014343750000001 0
+ 0.0010014359374999999 0
+ 0.0010014374999999999 0
+ 0.0010014390625 0
+ 0.001001440625 0
+ 0.0010014421875000001 0
+ 0.0010014437499999999 0
+ 0.0010014440280000001 0
+ 0.0010014453124999999 0
+ 0.001001446875 0
+ 0.0010014484375 0
+ 0.0010014500000000001 0
+ 0.0010014515624999999 0
+ 0.001001453125 0
+ 0.0010014546875 0
+ 0.00100145625 0
+ 0.0010014578125000001 0
+ 0.0010014593749999999 0
+ 0.0010014609375 0
+ 0.0010014625 0
+ 0.0010014640625000001 0
+ 0.0010014656250000001 0
+ 0.0010014671874999999 0
+ 0.00100146875 0
+ 0.0010014703125 0
+ 0.0010014718750000001 0
+ 0.0010014734375000001 0
+ 0.0010014749999999999 0
+ 0.0010014765625 0
+ 0.001001478125 0
+ 0.0010014796875000001 0
+ 0.0010014812499999999 0
+ 0.0010014828124999999 0
+ 0.001001484375 0
+ 0.0010014859375 0
+ 0.0010014875000000001 0
+ 0.0010014890624999999 0
+ 0.001001490625 0
+ 0.0010014921875 0
+ 0.00100149375 0
+ 0.0010014953125000001 0
+ 0.0010014968749999999 0
+ 0.0010014984375 0
+ 0.0010015 0
+ 0.0010015015625 0
+ 0.0010015031250000001 0
+ 0.0010015046874999999 0
+ 0.00100150625 0
+ 0.0010015078125 0
+ 0.0010015093750000001 0
+ 0.0010015109375000001 0
+ 0.0010015124999999999 0
+ 0.0010015140625 0
+ 0.001001515625 0
+ 0.0010015171875000001 0
+ 0.0010015187499999999 0
+ 0.0010015203124999999 0
+ 0.001001521875 0
+ 0.0010015234375 0
+ 0.0010015250000000001 0
+ 0.0010015265624999999 0
+ 0.0010015281249999999 0
+ 0.0010015296875 0
+ 0.00100153125 0
+ 0.0010015793109999999 0
+ 0.001003309375 0
+ 0.0010033109375 0
+ 0.0010033125000000001 0
+ 0.0010033140624999999 0
+ 0.001003315625 0
+ 0.0010033171875 0
+ 0.00100331875 0
+ 0.0010033203125000001 0
+ 0.0010033218749999999 0
+ 0.0010033234375 0
+ 0.001003325 0
+ 0.0010033265625000001 0
+ 0.0010033281250000001 0
+ 0.0010033296874999999 0
+ 0.00100333125 0
+ 0.0010033328125 0
+ 0.0010033343750000001 0
+ 0.0010033359375000001 0
+ 0.0010033374999999999 0
+ 0.0010033390625 0
+ 0.001003340625 0
+ 0.0010033421875000001 0
+ 0.0010033437499999999 0
+ 0.0010033453124999999 0
+ 0.001003346875 0
+ 0.0010033484375 0
+ 0.0010033500000000001 0
+ 0.0010033515624999999 0
+ 0.0010033531249999999 0
+ 0.0010033546875 0
+ 0.00100335625 0
+ 0.0010033578125000001 0
+ 0.0010033593749999999 0
+ 0.0010033609375 0
+ 0.0010033625 0
+ 0.0010033640625 0
+ 0.0010033656250000001 0
+ 0.0010033671874999999 0
+ 0.00100336875 0
+ 0.0010033703125 0
+ 0.0010033718750000001 0
+ 0.0010033734375000001 0
+ 0.0010033749999999999 0
+ 0.0010033765625 0
+ 0.001003378125 0
+ 0.0010033796875000001 0
+ 0.0010033812500000001 0
+ 0.0010033828124999999 0
+ 0.001003384375 0
+ 0.0010033859375 0
+ 0.0010033875000000001 0
+ 0.0010033890624999999 0
+ 0.0010033906249999999 0
+ 0.0010033921875 0
+ 0.00100339375 0
+ 0.0010033953125000001 0
+ 0.0010033968749999999 0
+ 0.0010033984375 0
+ 0.0010034 0
+ 0.0010034015625 0
+ 0.0010034031250000001 0
+ 0.0010034046874999999 0
+ 0.00100340625 0
+ 0.0010034078125 0
+ 0.001003409375 0
+ 0.0010034109375000001 0
+ 0.0010034124999999999 0
+ 0.0010034140625 0
+ 0.001003415625 0
+ 0.0010034171875000001 0
+ 0.0010034187500000001 0
+ 0.0010034203124999999 0
+ 0.001003421875 0
+ 0.0010034234375 0
+ 0.0010034250000000001 0
+ 0.0010034265625000001 0
+ 0.0010034281249999999 0
+ 0.0010034296875 0
+ 0.00100343125 0
+ 0.0010034328125000001 0
+ 0.0010034343749999999 0
+ 0.0010034359374999999 0
+ 0.0010034375 0
+ 0.0010034390625 0
+ 0.0010034406250000001 0
+ 0.0010034421874999999 0
+ 0.00100344375 0
+ 0.0010034453125 0
+ 0.001003446875 0
+ 0.0010034484375000001 0
+ 0.0010034499999999999 0
+ 0.0010034515625 0
+ 0.001003453125 0
+ 0.0010034546875 0
+ 0.0010034562500000001 0
+ 0.0010034578124999999 0
+ 0.001003459375 0
+ 0.0010034609375 0
+ 0.0010034625000000001 0
+ 0.0010034640625000001 0
+ 0.0010034656249999999 0
+ 0.0010034671875 0
+ 0.00100346875 0
+ 0.0010034703125000001 0
+ 0.0010034718749999999 0
+ 0.0010034734374999999 0
+ 0.001003475 0
+ 0.0010034765625 0
+ 0.0010034781250000001 0
+ 0.0010034796874999999 0
+ 0.0010034812499999999 0
+ 0.0010034828125 0
+ 0.001003484375 0
+ 0.0010034859375000001 0
+ 0.0010034874999999999 0
+ 0.0010034890625 0
+ 0.001003490625 0
+ 0.0010034921875 0
+ 0.0010034937500000001 0
+ 0.0010034953124999999 0
+ 0.001003496875 0
+ 0.0010034984375 0
+ 0.0010035000000000001 0
+ 0.0010035015625000001 0
+ 0.0010035031249999999 0
+ 0.0010035046875 0
+ 0.00100350625 0
+ 0.0010035078125000001 0
+ 0.0010050117670000001 0
+ 0.0010050124730000001 0
+ 0.0010051673819999999 0
+ 0.0010053265625000001 0
+ 0.0010053281249999999 0
+ 0.0010053296875 0
+ 0.00100533125 0
+ 0.0010053328125000001 0
+ 0.0010053343750000001 0
+ 0.0010053359374999999 0
+ 0.0010053375 0
+ 0.0010053390625 0
+ 0.0010053406250000001 0
+ 0.0010053421874999999 0
+ 0.0010053437499999999 0
+ 0.0010053453125 0
+ 0.001005346875 0
+ 0.0010053484375000001 0
+ 0.0010053499999999999 0
+ 0.0010053515625 0
+ 0.001005353125 0
+ 0.0010053546875 0
+ 0.0010053562500000001 0
+ 0.0010053578124999999 0
+ 0.001005359375 0
+ 0.0010053609375 0
+ 0.0010053625 0
+ 0.0010053640625000001 0
+ 0.0010053656249999999 0
+ 0.0010053671875 0
+ 0.00100536875 0
+ 0.0010053703125000001 0
+ 0.0010053718750000001 0
+ 0.0010053734374999999 0
+ 0.001005375 0
+ 0.0010053765625 0
+ 0.0010053781250000001 0
+ 0.0010053796874999999 0
+ 0.0010053812499999999 0
+ 0.0010053828125 0
+ 0.001005384375 0
+ 0.0010053859375000001 0
+ 0.0010053874999999999 0
+ 0.0010053890624999999 0
+ 0.001005390625 0
+ 0.0010053921875 0
+ 0.0010053937500000001 0
+ 0.0010053953124999999 0
+ 0.001005396875 0
+ 0.0010053984375 0
+ 0.0010054 0
+ 0.0010054015625000001 0
+ 0.0010054031249999999 0
+ 0.0010054046875 0
+ 0.00100540625 0
+ 0.0010054078125000001 0
+ 0.0010054093750000001 0
+ 0.0010054109374999999 0
+ 0.0010054125 0
+ 0.0010054140625 0
+ 0.0010054156250000001 0
+ 0.0010054171875000001 0
+ 0.0010054187499999999 0
+ 0.0010054203125 0
+ 0.001005421875 0
+ 0.0010054234375000001 0
+ 0.0010054249999999999 0
+ 0.0010054265624999999 0
+ 0.001005428125 0
+ 0.0010054296875 0
+ 0.0010054312500000001 0
+ 0.0010054328124999999 0
+ 0.0010054343749999999 0
+ 0.0010054359375 0
+ 0.001005436429 0
+ 0.0010054375 0
+ 0.0010054390625000001 0
+ 0.0010054406249999999 0
+ 0.0010054421875 0
+ 0.00100544375 0
+ 0.0010054453125 0
+ 0.0010054468750000001 0
+ 0.0010054484374999999 0
+ 0.00100545 0
+ 0.0010054515625 0
+ 0.0010054531250000001 0
+ 0.0010054546875000001 0
+ 0.0010054562499999999 0
+ 0.0010054578125 0
+ 0.001005459375 0
+ 0.0010054609375000001 0
+ 0.0010054625000000001 0
+ 0.0010054625979999999 0
+ 0.0010054640624999999 0
+ 0.001005465625 0
+ 0.0010054671875 0
+ 0.0010054687500000001 0
+ 0.0010054703124999999 0
+ 0.0010054718749999999 0
+ 0.0010054734375 0
+ 0.001005475 0
+ 0.0010054765625000001 0
+ 0.0010054781249999999 0
+ 0.0010054796874999999 0
+ 0.00100548125 0
+ 0.0010054828125 0
+ 0.0010054843750000001 0
+ 0.0010054859374999999 0
+ 0.0010054875 0
+ 0.0010054890625 0
+ 0.001005490625 0
+ 0.0010054921875000001 0
+ 0.0010054937499999999 0
+ 0.0010054953125 0
+ 0.001005496875 0
+ 0.0010054984375000001 0
+ 0.0010055000000000001 0
+ 0.0010055015624999999 0
+ 0.001005503125 0
+ 0.0010055046875 0
+ 0.0010055062500000001 0
+ 0.0010055078125000001 0
+ 0.0010055093749999999 0
+ 0.0010055109375 0
+ 0.0010055125 0
+ 0.0010055140625000001 0
+ 0.0010055156249999999 0
+ 0.0010055171874999999 0
+ 0.00100551875 0
+ 0.0010055203125 0
+ 0.0010055218750000001 0
+ 0.0010055234374999999 0
+ 0.001005525 0
+ 0.001005594838 0
+ 0.0010057609375 0
+ 0.0010057625000000001 0
+ 0.0010057640625000001 0
+ 0.0010057656249999999 0
+ 0.0010057671875 0
+ 0.00100576875 0
+ 0.0010057703125000001 0
+ 0.0010057718749999999 0
+ 0.0010057734374999999 0
+ 0.001005775 0
+ 0.0010057765625 0
+ 0.0010057781250000001 0
+ 0.0010057796874999999 0
+ 0.0010057812499999999 0
+ 0.0010057828125 0
+ 0.001005784375 0
+ 0.0010057859375000001 0
+ 0.0010057874999999999 0
+ 0.0010057890625 0
+ 0.001005790625 0
+ 0.0010057921875 0
+ 0.0010057937500000001 0
+ 0.0010057953124999999 0
+ 0.001005796875 0
+ 0.0010057984375 0
+ 0.0010058000000000001 0
+ 0.0010058015625000001 0
+ 0.0010058031249999999 0
+ 0.0010058046875 0
+ 0.00100580625 0
+ 0.0010058078125000001 0
+ 0.0010058093750000001 0
+ 0.0010058109374999999 0
+ 0.0010058125 0
+ 0.0010058140625 0
+ 0.0010058156250000001 0
+ 0.0010058171874999999 0
+ 0.0010058187499999999 0
+ 0.0010058203125 0
+ 0.001005821875 0
+ 0.0010058234375000001 0
+ 0.0010058249999999999 0
+ 0.0010058265624999999 0
+ 0.001005828125 0
+ 0.0010058296875 0
+ 0.0010058312500000001 0
+ 0.0010058328124999999 0
+ 0.001005834375 0
+ 0.0010058359375 0
+ 0.0010058375 0
+ 0.0010058390625000001 0
+ 0.0010058406249999999 0
+ 0.0010058421875 0
+ 0.00100584375 0
+ 0.0010058453125000001 0
+ 0.0010058468750000001 0
+ 0.0010058484374999999 0
+ 0.00100585 0
+ 0.0010058515625 0
+ 0.0010058531250000001 0
+ 0.0010058546875000001 0
+ 0.0010058562499999999 0
+ 0.0010058578125 0
+ 0.001005859375 0
+ 0.0010058609375000001 0
+ 0.0010058624999999999 0
+ 0.0010058640624999999 0
+ 0.001005865625 0
+ 0.0010058671875 0
+ 0.0010058687500000001 0
+ 0.0010058703124999999 0
+ 0.001005871875 0
+ 0.0010058734375 0
+ 0.001005875 0
+ 0.0010058765625000001 0
+ 0.0010058781249999999 0
+ 0.0010058796875 0
+ 0.00100588125 0
+ 0.0010058828125 0
+ 0.0010058843750000001 0
+ 0.0010058859374999999 0
+ 0.0010058875 0
+ 0.0010058890625 0
+ 0.0010058906250000001 0
+ 0.0010058921875000001 0
+ 0.0010058937499999999 0
+ 0.0010058953125 0
+ 0.001005896875 0
+ 0.0010058984375000001 0
+ 0.0010058999999999999 0
+ 0.0010059015624999999 0
+ 0.001005903125 0
+ 0.0010059046875 0
+ 0.0010059062500000001 0
+ 0.0010059078124999999 0
+ 0.0010059093749999999 0
+ 0.0010059109375 0
+ 0.0010059125 0
+ 0.0010059140625000001 0
+ 0.0010059156249999999 0
+ 0.0010059171875 0
+ 0.00100591875 0
+ 0.0010059203125 0
+ 0.0010059218750000001 0
+ 0.0010059234374999999 0
+ 0.001005925 0
+ 0.0010059265625 0
+ 0.0010059281250000001 0
+ 0.0010059296875000001 0
+ 0.0010059312499999999 0
+ 0.0010059328125 0
+ 0.001005934375 0
+ 0.0010059359375000001 0
+ 0.0010059375000000001 0
+ 0.0010059390624999999 0
+ 0.001005940625 0
+ 0.0010059421875 0
+ 0.0010059437500000001 0
+ 0.0010059453124999999 0
+ 0.0010059468749999999 0
+ 0.0010059484375 0
+ 0.00100595 0
+ 0.0010059515625000001 0
+ 0.0010059531249999999 0
+ 0.0010059546874999999 0
+ 0.00100595625 0
+ 0.0010059578125 0
+ 0.0010059593750000001 0
+ )
Vfixture_clock fixture_clock 0 PULSE(0 5 500n 1n 1n 499n 1u)
Vfixture_reset fixture_reset 0 PWL(0 0 1000000n 0 1000001n 5)
R1_2 0 n_SENSE7 910
R1_3 0 n_SENSE6 910
R1_4 0 n_SENSE5 910
R1_5 0 n_SENSE4 910
R1_6 0 n_SENSE3 910
R1_7 0 n_SENSE2 910
R1_8 0 n_SENSE1 910
R1_9 0 n_SENSE0 910
R2_2 n_p5V n_BASE6 4.7k
R2_3 n_p5V n_BASE0 4.7k
R2_4 n_p5V n_BASE1 4.7k
R2_5 n_p5V n_BASE4 4.7k
R2_6 n_p5V n_BASE7 4.7k
R2_7 n_p5V n_BASE5 4.7k
R2_8 n_p5V n_BASE2 4.7k
R2_9 n_p5V n_BASE3 4.7k
R9.1 n_ROW7 n_BASE7 3.9k
R9.2 n_ROW6 n_BASE6 3.9k
R9.3 n_ROW0 n_BASE0 3.9k
R9.4 n_ROW5 n_BASE5 3.9k
R9.5 n_ROW1 n_BASE1 3.9k
R9.6 n_ROW2 n_BASE2 3.9k
R9.7 n_ROW3 n_BASE3 3.9k
R9.8 n_ROW4 n_BASE4 3.9k
QV4.1 n_SENSE4 n_BASE4 n_p5V PNP_NOMINAL
QV4.2 n_SENSE6 n_BASE6 n_p5V PNP_NOMINAL
QV4.3 n_SENSE0 n_BASE0 n_p5V PNP_NOMINAL
QV4.4 n_SENSE1 n_BASE1 n_p5V PNP_NOMINAL
QV4.5 n_SENSE7 n_BASE7 n_p5V PNP_NOMINAL
QV4.6 n_SENSE5 n_BASE5 n_p5V PNP_NOMINAL
QV4.7 n_SENSE3 n_BASE3 n_p5V PNP_NOMINAL
QV4.8 n_SENSE2 n_BASE2 n_p5V PNP_NOMINAL
.model D_NOMINAL D(IS=1e-14 N=1)
.model NPN_NOMINAL NPN(IS=1e-14 BF=100 VAF=100)
.model PNP_NOMINAL PNP(IS=1e-14 BF=100 VAF=100)
.model CONTACT_NOMINAL SW(RON=100 ROFF=1t VT=2.5 VH=0)
.model SINK_NOMINAL SW(RON=20 ROFF=1t VT=2.5 VH=0)
Sdriver0 n_COL0 0 sink0 0 SINK_NOMINAL
Scontact0 n_COL0 n_ROW0 contact0 0 CONTACT_NOMINAL
Scontact1 n_COL0 n_ROW1 contact1 0 CONTACT_NOMINAL
Scontact2 n_COL0 n_ROW2 contact2 0 CONTACT_NOMINAL
Scontact3 n_COL0 n_ROW3 contact3 0 CONTACT_NOMINAL
Scontact4 n_COL0 n_ROW4 contact4 0 CONTACT_NOMINAL
Scontact5 n_COL0 n_ROW5 contact5 0 CONTACT_NOMINAL
Scontact6 n_COL0 n_ROW6 contact6 0 CONTACT_NOMINAL
Scontact7 n_COL0 n_ROW7 contact7 0 CONTACT_NOMINAL
Sdriver1 n_COL1 0 sink1 0 SINK_NOMINAL
Scontact8 n_COL1 n_ROW0 contact8 0 CONTACT_NOMINAL
Scontact9 n_COL1 n_ROW1 contact9 0 CONTACT_NOMINAL
Scontact10 n_COL1 n_ROW2 contact10 0 CONTACT_NOMINAL
Scontact11 n_COL1 n_ROW3 contact11 0 CONTACT_NOMINAL
Scontact12 n_COL1 n_ROW4 contact12 0 CONTACT_NOMINAL
Scontact13 n_COL1 n_ROW5 contact13 0 CONTACT_NOMINAL
Scontact14 n_COL1 n_ROW6 contact14 0 CONTACT_NOMINAL
Scontact15 n_COL1 n_ROW7 contact15 0 CONTACT_NOMINAL
Sdriver2 n_COL2 0 sink2 0 SINK_NOMINAL
Scontact16 n_COL2 n_ROW0 contact16 0 CONTACT_NOMINAL
Scontact17 n_COL2 n_ROW1 contact17 0 CONTACT_NOMINAL
Scontact18 n_COL2 n_ROW2 contact18 0 CONTACT_NOMINAL
Scontact19 n_COL2 n_ROW3 contact19 0 CONTACT_NOMINAL
Scontact20 n_COL2 n_ROW4 contact20 0 CONTACT_NOMINAL
Scontact21 n_COL2 n_ROW5 contact21 0 CONTACT_NOMINAL
Scontact22 n_COL2 n_ROW6 contact22 0 CONTACT_NOMINAL
Scontact23 n_COL2 n_ROW7 contact23 0 CONTACT_NOMINAL
Sdriver3 n_COL3 0 sink3 0 SINK_NOMINAL
Scontact24 n_COL3 n_ROW0 contact24 0 CONTACT_NOMINAL
Scontact25 n_COL3 n_ROW1 contact25 0 CONTACT_NOMINAL
Scontact26 n_COL3 n_ROW2 contact26 0 CONTACT_NOMINAL
Scontact27 n_COL3 n_ROW3 contact27 0 CONTACT_NOMINAL
Scontact28 n_COL3 n_ROW4 contact28 0 CONTACT_NOMINAL
Scontact29 n_COL3 n_ROW5 contact29 0 CONTACT_NOMINAL
Scontact30 n_COL3 n_ROW6 contact30 0 CONTACT_NOMINAL
Scontact31 n_COL3 n_ROW7 contact31 0 CONTACT_NOMINAL
Sdriver4 n_COL4 0 sink4 0 SINK_NOMINAL
Scontact32 n_COL4 n_ROW0 contact32 0 CONTACT_NOMINAL
Scontact33 n_COL4 n_ROW1 contact33 0 CONTACT_NOMINAL
Scontact34 n_COL4 n_ROW2 contact34 0 CONTACT_NOMINAL
Scontact35 n_COL4 n_ROW3 contact35 0 CONTACT_NOMINAL
Scontact36 n_COL4 n_ROW4 contact36 0 CONTACT_NOMINAL
Scontact37 n_COL4 n_ROW5 contact37 0 CONTACT_NOMINAL
Scontact38 n_COL4 n_ROW6 contact38 0 CONTACT_NOMINAL
Scontact39 n_COL4 n_ROW7 contact39 0 CONTACT_NOMINAL
Sdriver5 n_COL5 0 sink5 0 SINK_NOMINAL
Scontact40 n_COL5 n_ROW0 contact40 0 CONTACT_NOMINAL
Scontact41 n_COL5 n_ROW1 contact41 0 CONTACT_NOMINAL
Scontact42 n_COL5 n_ROW2 contact42 0 CONTACT_NOMINAL
Scontact43 n_COL5 n_ROW3 contact43 0 CONTACT_NOMINAL
Scontact44 n_COL5 n_ROW4 contact44 0 CONTACT_NOMINAL
Scontact45 n_COL5 n_ROW5 contact45 0 CONTACT_NOMINAL
Scontact46 n_COL5 n_ROW6 contact46 0 CONTACT_NOMINAL
Scontact47 n_COL5 n_ROW7 contact47 0 CONTACT_NOMINAL
Sdriver6 n_COL6 0 sink6 0 SINK_NOMINAL
Scontact48 n_COL6 n_ROW0 contact48 0 CONTACT_NOMINAL
Scontact49 n_COL6 n_ROW1 contact49 0 CONTACT_NOMINAL
Scontact50 n_COL6 n_ROW2 contact50 0 CONTACT_NOMINAL
Scontact51 n_COL6 n_ROW3 contact51 0 CONTACT_NOMINAL
Scontact52 n_COL6 n_ROW4 contact52 0 CONTACT_NOMINAL
Scontact53 n_COL6 n_ROW5 contact53 0 CONTACT_NOMINAL
Scontact54 n_COL6 n_ROW6 contact54 0 CONTACT_NOMINAL
Scontact55 n_COL6 n_ROW7 contact55 0 CONTACT_NOMINAL
Sdriver7 n_COL7 0 sink7 0 SINK_NOMINAL
Scontact56 n_COL7 n_ROW0 contact56 0 CONTACT_NOMINAL
Scontact57 n_COL7 n_ROW1 contact57 0 CONTACT_NOMINAL
Scontact58 n_COL7 n_ROW2 contact58 0 CONTACT_NOMINAL
Scontact59 n_COL7 n_ROW3 contact59 0 CONTACT_NOMINAL
Scontact60 n_COL7 n_ROW4 contact60 0 CONTACT_NOMINAL
Scontact61 n_COL7 n_ROW5 contact61 0 CONTACT_NOMINAL
Scontact62 n_COL7 n_ROW6 contact62 0 CONTACT_NOMINAL
Scontact63 n_COL7 n_ROW7 contact63 0 CONTACT_NOMINAL
Sdriver8 n_COL8 0 sink8 0 SINK_NOMINAL
Scontact64 n_COL8 n_ROW0 contact64 0 CONTACT_NOMINAL
Scontact65 n_COL8 n_ROW1 contact65 0 CONTACT_NOMINAL
Scontact66 n_COL8 n_ROW2 contact66 0 CONTACT_NOMINAL
Scontact67 n_COL8 n_ROW3 contact67 0 CONTACT_NOMINAL
Scontact68 n_COL8 n_ROW4 contact68 0 CONTACT_NOMINAL
Scontact69 n_COL8 n_ROW5 contact69 0 CONTACT_NOMINAL
Scontact70 n_COL8 n_ROW6 contact70 0 CONTACT_NOMINAL
Scontact71 n_COL8 n_ROW7 contact71 0 CONTACT_NOMINAL
Sdriver9 n_COL9 0 sink9 0 SINK_NOMINAL
Scontact72 n_COL9 n_ROW0 contact72 0 CONTACT_NOMINAL
Scontact73 n_COL9 n_ROW1 contact73 0 CONTACT_NOMINAL
Scontact74 n_COL9 n_ROW2 contact74 0 CONTACT_NOMINAL
Scontact75 n_COL9 n_ROW3 contact75 0 CONTACT_NOMINAL
Scontact76 n_COL9 n_ROW4 contact76 0 CONTACT_NOMINAL
Scontact77 n_COL9 n_ROW5 contact77 0 CONTACT_NOMINAL
Scontact78 n_COL9 n_ROW6 contact78 0 CONTACT_NOMINAL
Scontact79 n_COL9 n_ROW7 contact79 0 CONTACT_NOMINAL
Sdriver10 n_COL10 0 sink10 0 SINK_NOMINAL
Scontact80 n_COL10 n_ROW0 contact80 0 CONTACT_NOMINAL
Scontact81 n_COL10 n_ROW1 contact81 0 CONTACT_NOMINAL
Scontact82 n_COL10 n_ROW2 contact82 0 CONTACT_NOMINAL
Scontact83 n_COL10 n_ROW3 contact83 0 CONTACT_NOMINAL
Scontact84 n_COL10 n_ROW4 contact84 0 CONTACT_NOMINAL
Scontact85 n_COL10 n_ROW5 contact85 0 CONTACT_NOMINAL
Scontact86 n_COL10 n_ROW6 contact86 0 CONTACT_NOMINAL
Scontact87 n_COL10 n_ROW7 contact87 0 CONTACT_NOMINAL
Sdriver11 n_COL11 0 sink11 0 SINK_NOMINAL
Scontact88 n_COL11 n_ROW0 contact88 0 CONTACT_NOMINAL
Scontact89 n_COL11 n_ROW1 contact89 0 CONTACT_NOMINAL
Scontact90 n_COL11 n_ROW2 contact90 0 CONTACT_NOMINAL
Scontact91 n_COL11 n_ROW3 contact91 0 CONTACT_NOMINAL
Scontact92 n_COL11 n_ROW4 contact92 0 CONTACT_NOMINAL
Scontact93 n_COL11 n_ROW5 contact93 0 CONTACT_NOMINAL
Scontact94 n_COL11 n_ROW6 contact94 0 CONTACT_NOMINAL
Scontact95 n_COL11 n_ROW7 contact95 0 CONTACT_NOMINAL
Sdriver12 n_COL12 0 sink12 0 SINK_NOMINAL
Scontact96 n_COL12 n_ROW0 contact96 0 CONTACT_NOMINAL
Scontact97 n_COL12 n_ROW1 contact97 0 CONTACT_NOMINAL
Scontact98 n_COL12 n_ROW2 contact98 0 CONTACT_NOMINAL
Scontact99 n_COL12 n_ROW3 contact99 0 CONTACT_NOMINAL
Scontact100 n_COL12 n_ROW4 contact100 0 CONTACT_NOMINAL
Scontact101 n_COL12 n_ROW5 contact101 0 CONTACT_NOMINAL
Scontact102 n_COL12 n_ROW6 contact102 0 CONTACT_NOMINAL
Scontact103 n_COL12 n_ROW7 contact103 0 CONTACT_NOMINAL
Rlatch0 n_SENSE0 0 1g
Clatch0 n_SENSE0 0 10p
Rlatch1 n_SENSE1 0 1g
Clatch1 n_SENSE1 0 10p
Rlatch2 n_SENSE2 0 1g
Clatch2 n_SENSE2 0 10p
Rlatch3 n_SENSE3 0 1g
Clatch3 n_SENSE3 0 10p
Rlatch4 n_SENSE4 0 1g
Clatch4 n_SENSE4 0 10p
Rlatch5 n_SENSE5 0 1g
Clatch5 n_SENSE5 0 10p
Rlatch6 n_SENSE6 0 1g
Clatch6 n_SENSE6 0 10p
Rlatch7 n_SENSE7 0 1g
Clatch7 n_SENSE7 0 10p
R10.1 n_p5V n_TA_TAKT 560
R10.2 n_p5V n_TA_DATEN 560
R11.1 n_LED_SISO_N n_LED_SISO 130
R11.2 n_LED_CAPS_N n_LED_CAPS 130
C3.1 n_p5V 0 47u
C3.2 n_p5V 0 47u
C5.1 n_p5V 0 47n
C5.2 n_p5V 0 47n
C5.3 n_p5V 0 47n
C5.4 n_p5V 0 47n
C5.5 n_p5V 0 47n
L1.1 n_TA_TAKT L1_1_series 1u
RL1.1 L1_1_series n_CABLE_TAKT 1
L1.2 0 L1_2_series 1u
RL1.2 L1_2_series n_CABLE_GND 1
L1.3 n_p5V L1_3_series 1u
RL1.3 L1_3_series n_CABLE_5V 1
L1.4 n_TA_DATEN L1_4_series 1u
RL1.4 L1_4_series n_CABLE_DATEN 1
.model LED_NOMINAL D(IS=1e-20 N=2 RS=2)
Xdata n_D0 n_TA_DATEN driver_vp 0 TTL7406_DYNAMIC
Cdata_load n_CABLE_DATEN n_CABLE_GND 1000p
Rdata_load n_CABLE_DATEN n_CABLE_GND 100k
Xclock n_WR_N n_TA_TAKT driver_vp 0 TTL7406_DYNAMIC
Cclock_load n_CABLE_TAKT n_CABLE_GND 1000p
Rclock_load n_CABLE_TAKT n_CABLE_GND 100k
Bsiso_target siso_target 0 V=V(n_p5V)*(0.7-0.66*V(siso_intent)/5)
Rsiso_output siso_target n_LED_SISO_N 30
Dsiso_led n_p5V n_LED_SISO LED_NOMINAL
Bcaps_target caps_target 0 V=V(n_p5V)*(0.7-0.66*V(caps_intent)/5)
Rcaps_output caps_target n_LED_CAPS_N 30
Dcaps_led n_p5V n_LED_CAPS LED_NOMINAL
Vdriver_supply n_p5V driver_vp 0
* SN7406 topology from TI SDLS031A, page 2. Resistors are published nominal values.
* Generic semiconductor parameters are assumptions, NOT a vendor transistor model.
* No calibrated switching/storage, temperature, breakdown or package parasitics.
* Experimental calibrated storage; junction values and transistor uniformity are unmeasured.
.subckt TTL7406_DYNAMIC a y vp g params: input_br=.01
Rinput vp input_base 6k
Qinput phase_base input_base a TTL7406_INPUT_NPN
Dinput g a TTL7406_DIODE
Qphase phase_col phase_base phase_emit TTL7406_NPN
Dfeed feed phase_col TTL7406_DIODE
Rfeed vp feed 1.4k
Rdivider feed inverter_base 2k
Remitter phase_emit discharge_base 100
Rdischarge discharge_base g 1k
Qdischarge inverter_base discharge_base g TTL7406_NPN
Qinverter output_base inverter_base g TTL7406_NPN
Routput vp output_base 1.6k
Qoutput y output_base g TTL7406_NPN
.model TTL7406_NPN NPN(IS=1e-14 BF=100 BR=1 VAF=100 TF=0.8214285714285714n TR=0.047258979206049156n CJE=0.5p CJC=0.25p)
.model TTL7406_INPUT_NPN NPN(IS=1e-14 BF=100 BR={input_br} VAF=100 TF=0.8214285714285714n TR=0.047258979206049156n CJE=0.5p CJC=0.25p)
.model TTL7406_DIODE D(IS=1e-14 N=1)
.ends TTL7406_DYNAMIC
Cbus_A4_19 n_D0 0 1.2000000000000001e-11
Cbus_A5_14 n_D0 0 9.9999999999999994e-12
Cbus_A8_9 n_D0 0 1.2000000000000001e-11
Cbus_A4_18 n_D1 0 1.2000000000000001e-11
Cbus_A5_15 n_D1 0 9.9999999999999994e-12
Cbus_A8_10 n_D1 0 1.2000000000000001e-11
Cbus_A4_17 n_D2 0 1.2000000000000001e-11
Cbus_A5_12 n_D2 0 9.9999999999999994e-12
Cbus_A8_11 n_D2 0 1.2000000000000001e-11
Cbus_A4_16 n_D3 0 1.2000000000000001e-11
Cbus_A5_8 n_D3 0 9.9999999999999994e-12
Cbus_A8_13 n_D3 0 1.2000000000000001e-11
Cbus_A4_15 n_D4 0 1.2000000000000001e-11
Cbus_A5_7 n_D4 0 9.9999999999999994e-12
Cbus_A8_14 n_D4 0 1.2000000000000001e-11
Cbus_A4_14 n_D5 0 1.2000000000000001e-11
Cbus_A5_9 n_D5 0 9.9999999999999994e-12
Cbus_A8_15 n_D5 0 1.2000000000000001e-11
Cbus_A4_13 n_D6 0 1.2000000000000001e-11
Cbus_A5_10 n_D6 0 9.9999999999999994e-12
Cbus_A8_16 n_D6 0 1.2000000000000001e-11
Cbus_A4_12 n_D7 0 1.2000000000000001e-11
Cbus_A5_13 n_D7 0 9.9999999999999994e-12
Cbus_A8_17 n_D7 0 1.2000000000000001e-11
Bbus_low_0 n_D0 0 I=V(n_D0)*V(bus_low_0)/(5*222.22222222222223)
Bbus_high_0 n_p5V n_D0 I=(V(n_p5V)-V(n_D0))*V(bus_high_0)/(5*10400)
Bbus_low_1 n_D1 0 I=V(n_D1)*V(bus_low_1)/(5*222.22222222222223)
Bbus_high_1 n_p5V n_D1 I=(V(n_p5V)-V(n_D1))*V(bus_high_1)/(5*10400)
Bbus_low_2 n_D2 0 I=V(n_D2)*V(bus_low_2)/(5*222.22222222222223)
Bbus_high_2 n_p5V n_D2 I=(V(n_p5V)-V(n_D2))*V(bus_high_2)/(5*10400)
Bbus_low_3 n_D3 0 I=V(n_D3)*V(bus_low_3)/(5*222.22222222222223)
Bbus_high_3 n_p5V n_D3 I=(V(n_p5V)-V(n_D3))*V(bus_high_3)/(5*10400)
Bbus_low_4 n_D4 0 I=V(n_D4)*V(bus_low_4)/(5*222.22222222222223)
Bbus_high_4 n_p5V n_D4 I=(V(n_p5V)-V(n_D4))*V(bus_high_4)/(5*10400)
Bbus_low_5 n_D5 0 I=V(n_D5)*V(bus_low_5)/(5*222.22222222222223)
Bbus_high_5 n_p5V n_D5 I=(V(n_p5V)-V(n_D5))*V(bus_high_5)/(5*10400)
Bbus_low_6 n_D6 0 I=V(n_D6)*V(bus_low_6)/(5*222.22222222222223)
Bbus_high_6 n_p5V n_D6 I=(V(n_p5V)-V(n_D6))*V(bus_high_6)/(5*10400)
Bbus_low_7 n_D7 0 I=V(n_D7)*V(bus_low_7)/(5*222.22222222222223)
Bbus_high_7 n_p5V n_D7 I=(V(n_p5V)-V(n_D7))*V(bus_high_7)/(5*10400)
Bbus_low_8 n_D0 0 I=V(n_D0)*V(bus_low_8)/(5*214.28571428571431)
Bbus_high_8 n_p5V n_D0 I=(V(n_p5V)-V(n_D0))*V(bus_high_8)/(5*6500)
Bbus_low_9 n_D1 0 I=V(n_D1)*V(bus_low_9)/(5*214.28571428571431)
Bbus_high_9 n_p5V n_D1 I=(V(n_p5V)-V(n_D1))*V(bus_high_9)/(5*6500)
Bbus_low_10 n_D2 0 I=V(n_D2)*V(bus_low_10)/(5*214.28571428571431)
Bbus_high_10 n_p5V n_D2 I=(V(n_p5V)-V(n_D2))*V(bus_high_10)/(5*6500)
Bbus_low_11 n_D3 0 I=V(n_D3)*V(bus_low_11)/(5*214.28571428571431)
Bbus_high_11 n_p5V n_D3 I=(V(n_p5V)-V(n_D3))*V(bus_high_11)/(5*6500)
Bbus_low_12 n_D4 0 I=V(n_D4)*V(bus_low_12)/(5*214.28571428571431)
Bbus_high_12 n_p5V n_D4 I=(V(n_p5V)-V(n_D4))*V(bus_high_12)/(5*6500)
Bbus_low_13 n_D5 0 I=V(n_D5)*V(bus_low_13)/(5*214.28571428571431)
Bbus_high_13 n_p5V n_D5 I=(V(n_p5V)-V(n_D5))*V(bus_high_13)/(5*6500)
Bbus_low_14 n_D6 0 I=V(n_D6)*V(bus_low_14)/(5*214.28571428571431)
Bbus_high_14 n_p5V n_D6 I=(V(n_p5V)-V(n_D6))*V(bus_high_14)/(5*6500)
Bbus_low_15 n_D7 0 I=V(n_D7)*V(bus_low_15)/(5*214.28571428571431)
Bbus_high_15 n_p5V n_D7 I=(V(n_p5V)-V(n_D7))*V(bus_high_15)/(5*6500)
Bbus_low_16 n_D0 0 I=V(n_D0)*V(bus_low_16)/(5*22.5)
Bbus_high_16 n_p5V n_D0 I=(V(n_p5V)-V(n_D0))*V(bus_high_16)/(5*520)
Bbus_low_17 n_D1 0 I=V(n_D1)*V(bus_low_17)/(5*22.5)
Bbus_high_17 n_p5V n_D1 I=(V(n_p5V)-V(n_D1))*V(bus_high_17)/(5*520)
Bbus_low_18 n_D2 0 I=V(n_D2)*V(bus_low_18)/(5*22.5)
Bbus_high_18 n_p5V n_D2 I=(V(n_p5V)-V(n_D2))*V(bus_high_18)/(5*520)
Bbus_low_19 n_D3 0 I=V(n_D3)*V(bus_low_19)/(5*22.5)
Bbus_high_19 n_p5V n_D3 I=(V(n_p5V)-V(n_D3))*V(bus_high_19)/(5*520)
Bbus_low_20 n_D4 0 I=V(n_D4)*V(bus_low_20)/(5*22.5)
Bbus_high_20 n_p5V n_D4 I=(V(n_p5V)-V(n_D4))*V(bus_high_20)/(5*520)
Bbus_low_21 n_D5 0 I=V(n_D5)*V(bus_low_21)/(5*22.5)
Bbus_high_21 n_p5V n_D5 I=(V(n_p5V)-V(n_D5))*V(bus_high_21)/(5*520)
Bbus_low_22 n_D6 0 I=V(n_D6)*V(bus_low_22)/(5*22.5)
Bbus_high_22 n_p5V n_D6 I=(V(n_p5V)-V(n_D6))*V(bus_high_22)/(5*520)
Bbus_low_23 n_D7 0 I=V(n_D7)*V(bus_low_23)/(5*22.5)
Bbus_high_23 n_p5V n_D7 I=(V(n_p5V)-V(n_D7))*V(bus_high_23)/(5*520)
Abus [n_D7 n_D6 n_D5 n_D4 n_D3 n_D2 n_D1 n_D0] [dbus7 dbus6 dbus5 dbus4 dbus3 dbus2 dbus1 dbus0] data_receiver
Abus_low [dbus_low23 dbus_low22 dbus_low21 dbus_low20 dbus_low19 dbus_low18 dbus_low17 dbus_low16 dbus_low15 dbus_low14 dbus_low13 dbus_low12 dbus_low11 dbus_low10 dbus_low9 dbus_low8 dbus_low7 dbus_low6 dbus_low5 dbus_low4 dbus_low3 dbus_low2 dbus_low1 dbus_low0] [bus_low_23 bus_low_22 bus_low_21 bus_low_20 bus_low_19 bus_low_18 bus_low_17 bus_low_16 bus_low_15 bus_low_14 bus_low_13 bus_low_12 bus_low_11 bus_low_10 bus_low_9 bus_low_8 bus_low_7 bus_low_6 bus_low_5 bus_low_4 bus_low_3 bus_low_2 bus_low_1 bus_low_0] drive
Abus_high [dbus_high23 dbus_high22 dbus_high21 dbus_high20 dbus_high19 dbus_high18 dbus_high17 dbus_high16 dbus_high15 dbus_high14 dbus_high13 dbus_high12 dbus_high11 dbus_high10 dbus_high9 dbus_high8 dbus_high7 dbus_high6 dbus_high5 dbus_high4 dbus_high3 dbus_high2 dbus_high1 dbus_high0] [bus_high_23 bus_high_22 bus_high_21 bus_high_20 bus_high_19 bus_high_18 bus_high_17 bus_high_16 bus_high_15 bus_high_14 bus_high_13 bus_high_12 bus_high_11 bus_high_10 bus_high_9 bus_high_8 bus_high_7 bus_high_6 bus_high_5 bus_high_4 bus_high_3 bus_high_2 bus_high_1 bus_high_0] drive
Rbus_numerical0 n_D0 0 1e12
Rbus_numerical1 n_D1 0 1e12
Rbus_numerical2 n_D2 0 1e12
Rbus_numerical3 n_D3 0 1e12
Rbus_numerical4 n_D4 0 1e12
Rbus_numerical5 n_D5 0 1e12
Rbus_numerical6 n_D6 0 1e12
Rbus_numerical7 n_D7 0 1e12
Bwr_low n_WR_N 0 I=V(n_WR_N)*V(wr_low)/(5*222.22222222222223)
Bwr_high n_p5V n_WR_N I=(V(n_p5V)-V(n_WR_N))*V(wr_high)/(5*10400)
Cwr_cpu n_WR_N 0 9.9999999999999994e-12
Rwr_numerical n_WR_N 0 1e12
Awr_drive [dwr_low dwr_high] [wr_low wr_high] drive
Vcontact0 contact0 0 0
Vcontact1 contact1 0 0
Vcontact2 contact2 0 0
Vcontact3 contact3 0 0
Vcontact4 contact4 0 0
Vcontact5 contact5 0 0
Vcontact6 contact6 0 0
Vcontact7 contact7 0 0
Vcontact8 contact8 0 0
Vcontact9 contact9 0 0
Vcontact10 contact10 0 0
Vcontact11 contact11 0 0
Vcontact12 contact12 0 0
Vcontact13 contact13 0 0
Vcontact14 contact14 0 0
Vcontact15 contact15 0 0
Vcontact16 contact16 0 0
Vcontact17 contact17 0 0
Vcontact18 contact18 0 0
Vcontact19 contact19 0 0
Vcontact20 contact20 0 0
Vcontact21 contact21 0 0
Vcontact22 contact22 0 0
Vcontact23 contact23 0 0
Vcontact24 contact24 0 0
Vcontact25 contact25 0 0
Vcontact26 contact26 0 0
Vcontact27 contact27 0 0
Vcontact28 contact28 0 0
Vcontact29 contact29 0 0
Vcontact30 contact30 0 0
Vcontact31 contact31 0 0
Vcontact32 contact32 0 0
Vcontact33 contact33 0 0
Vcontact34 contact34 0 0
Vcontact35 contact35 0 0
Vcontact36 contact36 0 0
Vcontact37 contact37 0 0
Vcontact38 contact38 0 0
Vcontact39 contact39 0 0
Vcontact40 contact40 0 0
Vcontact41 contact41 0 0
Vcontact42 contact42 0 0
Vcontact43 contact43 0 0
Vcontact44 contact44 0 0
Vcontact45 contact45 0 0
Vcontact46 contact46 0 0
Vcontact47 contact47 0 0
Vcontact48 contact48 0 0
Vcontact49 contact49 0 0
Vcontact50 contact50 0 0
Vcontact51 contact51 0 0
Vcontact52 contact52 0 0
Vcontact53 contact53 0 0
Vcontact54 contact54 0 0
Vcontact55 contact55 0 0
Vcontact56 contact56 0 0
Vcontact57 contact57 0 0
Vcontact58 contact58 0 0
Vcontact59 contact59 0 0
Vcontact60 contact60 0 0
Vcontact61 contact61 0 PWL(0 0 5000000n 0 5000001n 5 1511000000n 5 1511000001n 0)
Vcontact62 contact62 0 0
Vcontact63 contact63 0 0
Vcontact64 contact64 0 0
Vcontact65 contact65 0 0
Vcontact66 contact66 0 0
Vcontact67 contact67 0 0
Vcontact68 contact68 0 0
Vcontact69 contact69 0 0
Vcontact70 contact70 0 PWL(0 0 31000000n 0 31000001n 5 1501000000n 5 1501000001n 0)
Vcontact71 contact71 0 0
Vcontact72 contact72 0 0
Vcontact73 contact73 0 0
Vcontact74 contact74 0 0
Vcontact75 contact75 0 0
Vcontact76 contact76 0 0
Vcontact77 contact77 0 0
Vcontact78 contact78 0 0
Vcontact79 contact79 0 0
Vcontact80 contact80 0 0
Vcontact81 contact81 0 0
Vcontact82 contact82 0 0
Vcontact83 contact83 0 0
Vcontact84 contact84 0 0
Vcontact85 contact85 0 0
Vcontact86 contact86 0 0
Vcontact87 contact87 0 0
Vcontact88 contact88 0 0
Vcontact89 contact89 0 0
Vcontact90 contact90 0 0
Vcontact91 contact91 0 0
Vcontact92 contact92 0 0
Vcontact93 contact93 0 0
Vcontact94 contact94 0 0
Vcontact95 contact95 0 0
Vcontact96 contact96 0 0
Vcontact97 contact97 0 0
Vcontact98 contact98 0 0
Vcontact99 contact99 0 0
Vcontact100 contact100 0 0
Vcontact101 contact101 0 0
Vcontact102 contact102 0 0
Vcontact103 contact103 0 0
Esiso_intent siso_intent 0 led0_v 0 1
Ecaps_intent caps_intent 0 led1_v 0 1
Edata receiver_data 0 n_CABLE_DATEN n_CABLE_GND 1
Eclock receiver_clock 0 n_CABLE_TAKT n_CABLE_GND 1
Amatrix [n_SENSE7 n_SENSE6 n_SENSE5 n_SENSE4 n_SENSE3 n_SENSE2 n_SENSE1 n_SENSE0] [dsense7 dsense6 dsense5 dsense4 dsense3 dsense2 dsense1 dsense0] data_receiver
Arxdata [receiver_data] [rx_data] data_receiver
.model data_receiver adc_bridge(in_low=.8 in_high=2)
Arxclock [receiver_clock] [rx_clock] clock_receiver
.model clock_receiver adc_bridge(in_low=1.4 in_high=1.4)
Afixture [fixture_clock fixture_reset] [fixture_clk fixture_reset_n] clock_receiver
Ahdl [fixture_clk fixture_reset_n dsense7 dsense6 dsense5 dsense4 dsense3 dsense2 dsense1 dsense0 rx_data rx_clock fixture_reset_n fixture_reset_n fixture_reset_n fixture_reset_n fixture_reset_n dbus7 dbus6 dbus5 dbus4 dbus3 dbus2 dbus1 dbus0] [dbus_low23 dbus_low22 dbus_low21 dbus_low20 dbus_low19 dbus_low18 dbus_low17 dbus_low16 dbus_low15 dbus_low14 dbus_low13 dbus_low12 dbus_low11 dbus_low10 dbus_low9 dbus_low8 dbus_low7 dbus_low6 dbus_low5 dbus_low4 dbus_low3 dbus_low2 dbus_low1 dbus_low0 dbus_high23 dbus_high22 dbus_high21 dbus_high20 dbus_high19 dbus_high18 dbus_high17 dbus_high16 dbus_high15 dbus_high14 dbus_high13 dbus_high12 dbus_high11 dbus_high10 dbus_high9 dbus_high8 dbus_high7 dbus_high6 dbus_high5 dbus_high4 dbus_high3 dbus_high2 dbus_high1 dbus_high0 dwr_low dwr_high dlogic_sink1 dlogic_sink0 dsink csink led1 led0 dcol12 dcol11 dcol10 dcol9 dcol8 dcol7 dcol6 dcol5 dcol4 dcol3 dcol2 dcol1 dcol0] hdl
.model hdl d_cosim simulation="/Users/ddanila/fun/dac-emulation/build/keyboard-controller-analog/bridge/ivlng.so" sim_args=["io.vvp"] delay=10n
+ lib_args=["/private/tmp/robotron-icarus-src/vvp/libvvp.so" "/Users/ddanila/fun/dac-emulation/build/keyboard-controller-analog/bridge/ivlng.vpi"]
Adrive [led1 led0] [led1_v led0_v] drive
Acolumns [dcol12 dcol11 dcol10 dcol9 dcol8 dcol7 dcol6 dcol5 dcol4 dcol3 dcol2 dcol1 dcol0] [sink12 sink11 sink10 sink9 sink8 sink7 sink6 sink5 sink4 sink3 sink2 sink1 sink0] drive
.model drive dac_bridge(out_low=0 out_high=5 out_undef=2.5 t_rise=1n t_fall=1n)
.options reltol=1e-08 vntol=1e-09 abstol=1e-15
.options minbreak=1f
.tran 6.25n 1.006e+06n
.save v(receiver_data) v(receiver_clock) v(n_D0) v(n_D1) v(n_D2) v(n_D3) v(n_D4) v(n_D5) v(n_D6) v(n_D7) v(n_p5V) i(Vdriver_supply) v(n_WR_N) v(wr_low) v(wr_high) @bwr_low[i] @bwr_high[i] v(n_p5V) v(n_p5V) v(n_TA_TAKT) v(n_TA_DATEN) v(L1_1_series) v(L1_2_series) v(L1_3_series) v(L1_4_series) v(n_CABLE_TAKT) v(n_CABLE_GND) v(n_CABLE_5V) v(n_CABLE_DATEN) i(L1.1) i(L1.2) i(L1.3) i(L1.4) v(n_D0) v(n_WR_N) i(Vdriver_supply) @bwr_low[i] @bwr_high[i]
.control
set numdgt=17
set wr_singlescale
set wr_vecnames
run
wrdata witness.txt v(receiver_data) v(receiver_clock)
wrdata network_witness.txt v(receiver_data) v(receiver_clock) v(n_D0) v(n_D1) v(n_D2) v(n_D3) v(n_D4) v(n_D5) v(n_D6) v(n_D7) v(n_p5V) i(Vdriver_supply) v(n_WR_N) v(wr_low) v(wr_high) @bwr_low[i] @bwr_high[i] v(n_TA_TAKT) v(n_TA_DATEN) v(L1_1_series) v(L1_2_series) v(L1_3_series) v(L1_4_series) v(n_CABLE_TAKT) v(n_CABLE_GND) v(n_CABLE_5V) v(n_CABLE_DATEN) i(L1.1) i(L1.2) i(L1.3) i(L1.4)
wrdata bus-trace.txt v(n_D0) v(n_D1) v(n_D2) v(n_D3) v(n_D4) v(n_D5) v(n_D6) v(n_D7) v(n_p5V)
wrdata driver-trace.txt i(Vdriver_supply)
wrdata wr-trace.txt v(n_WR_N) v(wr_low) v(wr_high) @bwr_low[i] @bwr_high[i] v(n_p5V)
quit
.endc
.end
