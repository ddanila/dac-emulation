Nominal logic-control fixture
Vcc n_p5V 0 5
R6.3 n_p5V n_LATCH_OE_N 1k
R6.6 n_p5V n_FF_PULLUP 1k
R9.9 n_p5V n_IO_ACTIVE 3.9k
Scontrol_latchEnable n_LATCH_OE_N 0 control_latchEnable_sink 0 CONTROL_OC_NOMINAL
Scontrol_ioActive n_IO_ACTIVE 0 control_ioActive_sink 0 CONTROL_OC_NOMINAL
.model CONTROL_OC_NOMINAL SW(Ron=20 Roff=1e12 Vt=2.5 Vh=0)
Venable control_latchEnable_sink 0 PWL(0 0 200n 0 201n 5 400n 5 401n 0 2u 0)
Vio control_ioActive_sink 0 PWL(0 0 600n 0 601n 5 800n 5 801n 0 2u 0)
.control
set wr_singlescale
set wr_vecnames
set numdgt=17
tran .25n 2u
wrdata trace.txt v(n_LATCH_OE_N) v(n_FF_PULLUP) v(n_IO_ACTIVE)
quit
.endc
.end
