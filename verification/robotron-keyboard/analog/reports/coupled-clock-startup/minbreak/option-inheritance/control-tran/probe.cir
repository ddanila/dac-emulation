Option inheritance
V1 n 0 1
R1 n 0 1k
.options reltol=1e-7 minbreak=1f
.control
tran 1n 2n
snsave state.bin
quit
.endc
.end
