Single column switch with exact captured release timestamp
Vcc supply 0 5
Rpull supply output 560
Cload output 0 20p
Sdriver output 0 drive 0 sinkmodel
.model sinkmodel SW(RON=20 ROFF=1t VT=2.5 VH=0)
Areplay [dout] replay
.model replay d_source(input_file="stimulus.txt")
Adac [dout] [drive] dac
.model dac dac_bridge(out_low=0 out_high=5 out_undef=2.5 t_rise=1n t_fall=1n)
.options reltol=1e-7 vntol=1e-9 abstol=1e-15
.save v(drive) v(output)
.control
set wr_singlescale
set wr_vecnames
tran .0625n 104u
set numdgt=17
eprint dout > events.txt
print time[length(time)-1] v(drive)[length(time)-1] v(output)[length(time)-1] > endpoint.txt
quit
.endc
.end
