I8282 published disable-load response
Vbias bias 0 1.5
Rload bias out 180
Cleffective out 0 3.3e-10 IC=2.9651162790697674
Ileak out 0 -5.0000000000000002e-05
.options reltol=1e-8 abstol=1e-12
.control
tran 0.01n 100n 0 0.01n uic
meas tran edge_time WHEN v(out)=2.8651162790697673 FALL=1
quit
.endc
.end
