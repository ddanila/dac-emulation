I8282 enabled-output candidate under published load
Vdrive drive 0 0
Rdriver drive out 22.5
Vbias bias 0 2.0099999999999998
Rload bias out 78
Cload out 0 3e-10 IC=2.6021341463414633
Cdevice out 0 3e-11 IC=2.6021341463414633
.options reltol=1e-8 abstol=1e-12
.control
tran 0.05n 200n 0 0.05n uic
meas tran edge_time WHEN v(out)=1.5 FALL=1
quit
.endc
.end
