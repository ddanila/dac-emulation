I8282 finite drive ramp with final-state resistance
Vdrive drive 0 5
Rdriver drive out 250
Vbias bias 0 2.0099999999999998
Rload bias out 78
Cload out 0 3e-10 IC=0.4499999999999999
.options reltol=1e-8 abstol=1e-12
.control
tran 0.02n 300n 0 0.02n uic
meas tran from_time WHEN v(out)=0.80000000000000004 RISE=1
meas tran to_time WHEN v(out)=2 RISE=1
meas tran propagation_time WHEN v(out)=1.5 RISE=1
quit
.endc
.end
