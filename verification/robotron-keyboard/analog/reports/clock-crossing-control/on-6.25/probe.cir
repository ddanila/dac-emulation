External clock ADC and bridge timing control
Vclock clock 0 PULSE(0 5 500n 1n 1n 499n 1u)
Ainput [clock] [clk] receiver
.model receiver adc_bridge(in_low=1.4 in_high=1.4)
Ahdl [clk] [q] hdl
.model hdl d_cosim simulation="/Users/ddanila/fun/dac-emulation/build/keyboard-controller-analog/bridge/ivlng.so" sim_args=["io.vvp"] delay=10n
+ lib_args=["/private/tmp/robotron-icarus-src/vvp/libvvp.so" "/Users/ddanila/fun/dac-emulation/build/keyboard-controller-analog/rollback-time-bridge-postreset/ivlng.vpi"]
Adac [q] [out] drive
.model drive dac_bridge(out_low=0 out_high=5 out_undef=2.5 t_rise=1n t_fall=1n)
Rload out 0 1k
.options reltol=1e-8 vntol=1e-9 abstol=1e-15 minbreak=1f trtol=.25
.save v(clock) v(out)
.tran 6.25n 1.1091m
.control
set filetype=binary
run waveform.raw
quit
.endc
.end
