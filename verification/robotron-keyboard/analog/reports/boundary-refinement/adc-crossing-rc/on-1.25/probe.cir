Linear receiver threshold timing diagnostic
Vin drive 0 PWL(0 0 10n 0 10.001n 5)
Rinput drive source 1k
Cinput source 0 10p
Ainput [source] [digital] receiver
.model receiver adc_bridge(in_low=.8 in_high=2)
Adac [digital] [intent] drive
.model drive dac_bridge(out_low=0 out_high=5 out_undef=2.5 t_rise=1p t_fall=1p)
Rload intent 0 1g
.options reltol=1e-7 vntol=1e-9 abstol=1e-15
.control
set wr_singlescale
set wr_vecnames
set numdgt=17
tran 1.25n 50n 0 1.25n
wrdata trace.txt v(source) v(intent)
quit
.endc
.end
