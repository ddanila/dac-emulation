I8282 enabled-output candidate under published load
Vdrive drive 0 4.5
Rdriver drive out 125
Vbias bias 0 2.0099999999999998
Rload bias out 78
Cload out 0 3e-10 IC=0
.options reltol=1e-8 abstol=1e-12
.control
tran 0.05n 200n 0 0.05n uic
meas tran edge_time TRIG v(out) VAL=0.8 RISE=1 TARG v(out) VAL=2.0 RISE=1
quit
.endc
.end
