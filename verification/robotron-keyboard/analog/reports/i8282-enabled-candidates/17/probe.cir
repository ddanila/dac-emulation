I8282 enabled-output candidate under published load
Vdrive drive 0 0
Rdriver drive out 22.5
Iload out 0 -0.02
.control
op
print v(out)
quit
.endc
.end
