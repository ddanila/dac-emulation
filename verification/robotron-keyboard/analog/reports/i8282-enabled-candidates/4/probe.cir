I8282 enabled-output candidate under published load
Vdrive drive 0 5
Rdriver drive out 125
Iload out 0 0.0050000000000000001
.control
op
print v(out)
quit
.endc
.end
