DC output endpoint probe
Vcc vcc 0 4.75
Rhigh vcc high 10400
Rlow low 0 222.22222222222223
Ihigh high 0 0
Ilow 0 low 0
.control
set numdgt=17
set wr_singlescale
set wr_vecnames
op
wrdata trace.txt v(high) v(low)
quit
.endc
.end
