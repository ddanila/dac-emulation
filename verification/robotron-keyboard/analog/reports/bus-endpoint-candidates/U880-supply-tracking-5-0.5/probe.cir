DC output endpoint probe
Vcc vcc 0 5
Bhigh vcc high I=(V(vcc)-V(high))/((V(vcc)-2.3999999999999999)/0.00025000000000000001)
Rlow low 0 222.22222222222223
Ihigh high 0 0.000125
Ilow 0 low 0.00089999999999999998
.control
set numdgt=17
set wr_singlescale
set wr_vecnames
op
wrdata trace.txt v(high) v(low)
quit
.endc
.end
