Recorded D1 boundary: original driver and load equations
Cbus_A4_18 n_D1 0 4.9999999999999997e-12 IC=4.9673144176811865
Cbus_A5_15 n_D1 0 9.9999999999999994e-12 IC=4.9673144176811865
Cbus_A8_10 n_D1 0 1.2000000000000001e-11 IC=4.9673144176811865
Bbus_low_1 n_D1 0 I=V(n_D1)*V(bus_low_1)/(5*222.22222222222223)
Bbus_high_1 n_p5V n_D1 I=(V(n_p5V)-V(n_D1))*V(bus_high_1)/(5*10400)
Bbus_low_9 n_D1 0 I=V(n_D1)*V(bus_low_9)/(5*214.28571428571431)
Bbus_high_9 n_p5V n_D1 I=(V(n_p5V)-V(n_D1))*V(bus_high_9)/(5*6500)
Bbus_low_17 n_D1 0 I=V(n_D1)*V(bus_low_17)/(5*22.5)
Bbus_high_17 n_p5V n_D1 I=(V(n_p5V)-V(n_D1))*V(bus_high_17)/(5*520)
Rbus_numerical1 n_D1 0 1e12
V_n_p5V n_p5V 0 PWL(0 4.9676262075561786 1.0000000003410059e-10 4.9676262156622197 3.0000000010230177e-10 4.9676262318742905 6.5000000000481339e-10 4.9676262602453729 9.9999999990732502e-10 4.9676262886164064 1.0699999998444593e-09 4.967626294290608 1.2099999997187277e-09 4.9676263056390066 1.4899999996841051e-09 4.9676263283357764 1.99999999981465e-09 4.9676263696761787 3.0200000000757399e-09 4.9676264523565461 5.0600000005979195e-09 4.9676266177163768 9.1400000016422789e-09 4.9676269484306204 1.7300000003730998e-08 4.9676276098374599 3.3620000007908435e-08 4.9676289325645513 6.626000001626331e-08 4.9676315776723285 1.1626000001618321e-07 4.9676356287188437 1.6626000001610311e-07 4.9676396786819081 2.1626000001602301e-07 4.9676437275617813 2.6626000001594291e-07 4.967647775358718 3.1626000001586281e-07 4.9676518220729813 3.6626000001578271e-07 4.9676558677048339 4.1626000001570261e-07 4.9676599122545442 4.5813000000777607e-07 4.9676632983281435 4.9999999999984952e-07 4.9676666836432428 5.0009999999988362e-07 4.9676666917276302 5.0029999999995182e-07 4.9676667078963979 5.0064999999985434e-07 4.9676667361916991 5.0099999999975685e-07 4.967666764486947 5.0106999999969398e-07 4.9676667701459909 5.0120999999956825e-07 4.9676667814640751 5.0129999999985915e-07 4.9676667887399759 5.0148000000044095e-07 4.9676668032917695 5.0184000000160454e-07 4.967666832395329 5.0256000000393174e-07 4.9676668906022821 5.0400000000858612e-07 4.9676670070155184 5.0688000001789489e-07 4.9676672398393018 5.1264000003651243e-07 4.9676677054760985 5.2416000007374751e-07 4.9676686367066383 5.4720000014821767e-07 4.9676704989955285 5.9328000029715798e-07 4.9676742228846145 6.4328000029707788e-07 4.9676782625243305 6.9328000029699778e-07 4.9676823010833946 7.4328000029691768e-07 4.967686338562074 7.9328000029683758e-07 4.9676903749606458 8.4328000029675748e-07 4.9676944102793854 8.9328000029667738e-07 4.9676984445185592 9.4328000029659728e-07 4.9677024776784435 9.7164000014814816e-07 4.9677047648071113 9.9999999999991589e-07 4.9677070515886879 1.00009999999995e-06 4.9677070596514712 1.0003000000000182e-06 4.9677070757770272 1.0006499999999207e-06 4.9677071039967169 1.0009999999998232e-06 4.967707132216364 1.0010699999997603e-06 4.9677071378602875 1.0012099999996346e-06 4.9677071491481293 1.0014899999996e-06 4.9677071717237862 1.0019999999997305e-06 4.967707212843588 1.0030199999999916e-06 4.967707295082743 1.0050600000005138e-06 4.9677074595601596 1.0091400000015582e-06 4.9677077885096148 1.0173000000036469e-06 4.9677084463869727 1.0336200000078243e-06 4.9677097620555015 1.0662600000161792e-06 4.9677123930478713 1.1162600000160991e-06 4.9677164224759709 1.166260000016019e-06 4.9677204508260138 1.2162600000159389e-06 4.9677244780982788 1.2662600000158588e-06 4.9677285042930457 1.3162600000157787e-06 4.9677325294105916 1.3662600000156986e-06 4.9677365534511937 1.4162600000156185e-06 4.9677405764151237 1.458130000007692e-06 4.9677439444170117 1.4999999999997654e-06 4.9677473116642634 1.5049999999997357e-06 4.967747713715835 1.505999999999643e-06 4.9677477941257155 1.5079999999994577e-06 4.9677479549437598 1.511999999999087e-06 4.9677482765764038 1.5199999999983456e-06 4.9677489198210454 1.5359999999968628e-06 4.9677502062277288 1.5679999999938972e-06 4.9677527787106248 1.6179999999938171e-06 4.9677567973332613 1.667999999993737e-06 4.9677608148806547 1.7179999999936569e-06 4.9677648313530751 1.7679999999935768e-06 4.9677688467508023 1.8179999999934967e-06 4.9677728610741188 1.8679999999934166e-06 4.9677768743233095 1.9179999999933365e-06 4.9677808864986455 1.9589999999966926e-06 4.9677841756813015 2.0000000000000486e-06 4.9677874641422459 2.0001000000000827e-06 4.9677874721619988 2.0003000000001509e-06 4.9677874882014956 2.0006500000000534e-06 4.9677875162705636 2.0009999999999559e-06 4.967787544339572 2.0010699999998931e-06 4.9677875499533704 2.0012099999997673e-06 4.9677875611809625 2.0014899999997327e-06 4.9677875836361149 2.0019999999998633e-06 4.9677876245364336 2.0030200000001244e-06 4.9677877063366234 2.0050600000006465e-06 4.9677878699361147 2.0091400000016909e-06 4.9677881971297397 2.0173000000037796e-06 4.9677888514955484 2.033620000007957e-06 4.9677901601414636 2.0662600000163119e-06 4.9677927770903896 2.1162600000162318e-06 4.9677967850104823 2.1662600000161517e-06 4.9678007918581333 2.2162600000160716e-06 4.9678047976336286 2.2662600000159915e-06 4.9678088023372453 2.3162600000159114e-06 4.9678128059692659 2.3662600000158313e-06 4.9678168085299736 2.4162600000157512e-06 4.9678208100196555 2.4581300000078247e-06 4.9678241600433486 2.4999999999998981e-06 4.9678275093163524 2.5000999999999322e-06 4.9678275173146664 2.5003000000000004e-06 4.9678275333112865 2.500649999999903e-06 4.9678275613053309 2.5009999999998055e-06 4.9678275892993247 2.5010699999997426e-06 4.9678275948981128 2.5012099999996169e-06 4.9678276060956845 2.5012999999999078e-06 4.967827613294121 2.5014800000004896e-06 4.9678276276909923 2.5018400000016532e-06 4.9678276564847073 2.5025600000039804e-06 4.9678277140719587 2.5040000000086347e-06 4.9678278292457794 2.5068800000179435e-06 4.9678280595907669 2.5112999999998484e-06 4.9678284130994168 2.5118760000016668e-06 4.96782845916682 2.5130280000053035e-06 4.9678285513013423 2.5153320000127939e-06 4.9678287355686974 2.5199400000277747e-06 4.9678291040966132 2.5291560000575194e-06 4.9678298411251758 2.5475880001170088e-06 4.9678313150732576 2.5844520002362044e-06 4.9678342625332252 2.6344520002361243e-06 4.9678382593524191 2.6844520002360442e-06 4.9678422551021093 2.7344520002359641e-06 4.9678462497825713 2.784452000235884e-06 4.967850243394091 2.8344520002358039e-06 4.9678542359369624 2.8844520002357238e-06 4.9678582274114591 2.9344520002356437e-06 4.9678622178178644 2.9672260001179125e-06 4.9678648328700632 2.9999999999999645e-06 4.9678674474635569 3.0000999999999986e-06 4.9678674554404987 3.0003000000000668e-06 4.9678674713943716 3.0006499999999693e-06 4.9678674993136047 3.0009999999998718e-06 4.9678675272327846 3.001069999999809e-06 4.9678675328166104 3.0012099999996832e-06 4.9678675439842577 3.0014899999996486e-06 4.9678675663195344 3.0019999999997792e-06 4.967867607001514 3.0030200000000402e-06 4.9678676883650459 3.0050600000005624e-06 4.9678678510912198 3.0091400000016068e-06 4.9678681765382304 3.0119999999997198e-06 4.9678684046659676 3.0120073520312467e-06 4.9678684052518047 3.0120220560943007e-06 4.9678684064227561 3.0120514642204086e-06 4.9678684087597045 3.0121102804726244e-06 4.9678684134125577 3.0122279129770561e-06 4.9678684226340559 3.0124631779861362e-06 4.9678684407403155 3.0129337080042964e-06 4.9678684756091567 3.0132348686766515e-06 4.9678684972749609 3.0135914349197629e-06 4.967868522835432 3.0139627095852883e-06 4.9678685494554635 3.0147052589163392e-06 4.967868602711369 3.016190357578441e-06 4.9678687092862086 3.0183097521391169e-06 4.9678688615244484 3.0184068898265505e-06 4.9678688685061791 3.0186011652014177e-06 4.9678688824703476 3.0189897159513691e-06 4.9678689104029301 3.0193097521390242e-06 4.9678689334162138 3.0194840032100618e-06 4.967868945947453 3.0198325053523538e-06 4.9678689710121944 3.0205295096369378e-06 4.967869021155245 3.0219235182061058e-06 4.9678691214953554 3.0241116967082149e-06 4.9678692791436267 3.0242086352097117e-06 4.967869286131835 3.0244025122124884e-06 4.9678693001089353 3.0247902662180418e-06 4.9678693280672457 3.0251116967081222e-06 4.9678693512494325 3.0252852672042058e-06 4.9678693637687621 3.0256324081963729e-06 4.9678693888095999 3.0263266901804902e-06 4.9678694389043567 3.0277152541489417e-06 4.9678695391459708 3.029907747478626e-06 4.9678696975643284 3.0323934483297236e-06 4.967869877374377 3.0346461047591703e-06 4.9678700405135707 3.0368579413645336e-06 4.9678702008676447 3.0390221428943254e-06 4.9678703579305887 3.0412547698324688e-06 4.9678705201258264 3.0434585961314382e-06 4.9678706803927968 3.0456899269559745e-06 4.9678708428241922 3.0478921795146739e-06 4.9678710032991242 3.0501161559816359e-06 4.9678711655169252 3.0502129813563938e-06 4.9678711725831892 3.0504066321059096e-06 4.9678711867163186 3.050793933605158e-06 4.9678712149861886 3.0511161559815432e-06 4.9678712385111305 3.0512893425711785e-06 4.9678712511561631 3.0516357157506658e-06 4.9678712764481405 3.0523284621094236e-06 4.9678713270435688 3.0537139548269393e-06 4.967871428280124 3.0559088928521112e-06 4.9678715887858615 3.0583929601468544e-06 4.9678717706157371 3.0606472216664939e-06 4.9678719357891223 3.0611161559814838e-06 4.9678719701682752 3.0613372026418433e-06 4.9678719863770198 3.0613920063930072e-06 4.9678719903957163 3.0614879129573815e-06 4.9678719974285759 3.0615144585243413e-06 4.9678719993752125 3.0615609132665211e-06 4.9678720027818848 3.0615737712754495e-06 4.9678720037248141 3.0615962727915079e-06 4.967872005374951 3.0616045544249165e-06 4.9678720059822901 3.0616098677673474e-06 4.9678720063719446 3.0616129118197707e-06 4.9678720065951811 3.061614691158383e-06 4.9678720067256705 3.061615727424508e-06 4.9678720068016711 3.0616164009239586e-06 4.9678720068206275 3.0616170327904795e-06 4.9678720068098459 3.0616175295513151e-06 4.9678720068013638 3.0616181141201668e-06 4.9678720067913789 3.0616192832576532e-06 4.9678720067714126 3.061621621532843e-06 4.9678720067314464 3.0616262980832226e-06 4.9678720066512785 3.0616356511839818e-06 4.96787200649017 3.0616543573855001e-06 4.9678720061648951 3.0616917697885368e-06 4.967872005502004 3.0617665945946101e-06 4.9678720041269262 3.0619162442067568e-06 4.9678720011797903 3.0622155434308334e-06 4.9678719944992222 3.0628141418792033e-06 4.9678719780058351 3.0640113387759432e-06 4.9678719325956919 3.0664057325692062e-06 4.9678717929643987 3.0691268298945352e-06 4.9678715572364966 3.0722518989335836e-06 4.9678711892312526 3.0755930962055641e-06 4.9678706860596211 3.0797431498758542e-06 4.9678699130234598 3.0846132153682267e-06 4.9678688133354889 3.0909839668516546e-06 4.9678670977340449 3.0990912256400032e-06 4.9678645384019724 3.1109055103721583e-06 4.9678602794413562 3.1199775501265618e-06 4.9678567530740239 3.1209775501264692e-06 4.967856357303515 3.1219510434603737e-06 4.967855971855208 3.123898030127966e-06 4.96785520097289 3.1277920034631507e-06 4.9678536634129449 3.128792003463058e-06 4.9678532707151737 3.1298847767947339e-06 4.9678528431101174 3.1309775501264098e-06 4.9678524163238169 3.1311961047927449e-06 4.9678523312021197 3.1316332141254153e-06 4.9678521611058963 3.132507432790756e-06 4.9678518218389085 3.1342558701214374e-06 4.9678511474254785 3.1377527447828003e-06 4.9678498183222519 3.1447464941055259e-06 4.9678472631046562 3.1570238457376103e-06 4.9678432293265429 3.169967668616375e-06 4.9678397649865822 3.1792744972648345e-06 4.9678378570039197 3.1880261083733815e-06 4.9678365411230887 3.1968863574336447e-06 4.9678356839470403 3.2083031602789854e-06 4.9678352541906792 3.2220961031015957e-06 4.9678356452631505 3.2314900035761498e-06 4.9678364024825648 3.2404165366069129e-06 4.9678374117559896 3.2494156640850563e-06 4.9678386443914411 3.2612424525238319e-06 4.9678404679639492 3.2737456763902439e-06 4.9678424924965698 3.2846521856703687e-06 4.9678442122203617 3.2945975668686404e-06 4.9678456534960667 3.3046574861731251e-06 4.9678469227633295 3.3152066651748191e-06 4.9678479987362989 3.3303558952639534e-06 4.9678490222483056 3.3437543430208262e-06 4.9678493948008882 3.3539459505889033e-06 4.9678493520094475 3.3641136639650168e-06 4.9678490543044704 3.3743154896168515e-06 4.967848534067735 3.3869655327685086e-06 4.9678476466251107 3.4044499062661424e-06 4.9678461391319582 3.4211022211468912e-06 4.9678445836886231 3.4355727319176476e-06 4.967843283430839 3.4485631791891271e-06 4.9678422458589502 3.4610935139738671e-06 4.9678414140848863 3.4735426313870204e-06 4.967840781454238 3.4867713156934172e-06 4.9678403328401126 3.4933856578466156e-06 4.9678401943029913 3.499999999999814e-06 4.967840109949317 3.5005983760835226e-06 4.9678401051125309 3.5009999999999382e-06 4.9678401019589797 3.5011196752167233e-06 4.9678401010633797 3.5013590256500766e-06 4.9678400993049756 3.5015983760834299e-06 4.9678400976446575 3.5020770769501365e-06 4.9678400945835648 3.5030344786835498e-06 4.9678400889772165 3.5049492821503762e-06 4.9678400808192604 3.5087788890840292e-06 4.9678400763008312 3.5164381029513352e-06 4.9678401107903012 3.5263212535476419e-06 4.9678402298151756 3.5366371995170561e-06 4.967840424697461 3.5470283681060533e-06 4.9678406709175782 3.5591078799636269e-06 4.9678409881120986 3.5749257219813875e-06 4.9678413977015303 3.5938740270806142e-06 4.9678417977554998 3.6103909770127292e-06 4.9678420097117213 3.624105672399465e-06 4.9678420648991182 3.6362934308278166e-06 4.9678420174844904 3.6490725321414175e-06 4.9678418753748659 3.6605790223616895e-06 4.9678416756352357 3.6731371480557603e-06 4.9678413949046796 3.6907685852015457e-06 4.9678409264675061 3.7137126618050267e-06 4.9678402657667231 3.7344122790518557e-06 4.9678396945669894 3.7514968602573358e-06 4.9678392847769048 3.7659442756333549e-06 4.967838998563459 3.7783546281034298e-06 4.9678388008642509 3.789912918107782e-06 4.96783865590454 3.8015502303375293e-06 4.9678385446673845 3.8138771296047057e-06 4.9678384589551152 3.8323647086728214e-06 4.9678383742681893 3.8568359771468802e-06 4.9678382997289789 3.8780099450427472e-06 4.9678382298403774 3.8938022094603571e-06 4.9678381542652046 3.9079113781151625e-06 4.9678380614589592 3.9210317374111393e-06 4.9678379511854374 3.9329965694668168e-06 4.9678378304777766 3.9453808124334435e-06 4.9678376868723522 3.9579144787134195e-06 4.9678375249747413 3.9752330372180237e-06 4.9678372812056217 3.9876165186091689e-06 4.9678370974959396 4.0000000000000972e-06 4.9678369108669145 4.0001000000001313e-06 4.9678369093562722 4.0003000000001995e-06 4.9678369063351306 4.000650000000102e-06 4.9678369010488428 4.0010000000000046e-06 4.9678368957635257 4.0010699999999417e-06 4.9678368947066067 4.001209999999816e-06 4.9678368925928567 4.0014899999997813e-06 4.9678368883659072 4.0019999999999119e-06 4.9678368806702791 4.003020000000173e-06 4.9678368652920284 4.0050600000006951e-06 4.9678368345654089 4.0091400000017395e-06 4.9678367733365478 4.0173000000038282e-06 4.9678366521962998 4.0336200000080057e-06 4.9678364179349233 4.0507049849855536e-06 4.9678361876985546 4.0647118061357557e-06 4.9678360123778482 4.0763612613181621e-06 4.9678358760593868 4.0896232236938782e-06 4.9678357306267866 4.1017938909330889e-06 4.9678356051133283 4.1190755976415559e-06 4.9678354365741448 4.1407302293627879e-06 4.96783523437594 4.1605746585030891e-06 4.9678350504932816 4.1757842378362716e-06 4.967834906321567 4.1903295049127744e-06 4.9678347635073612 4.204670839506831e-06 4.9678346168833381 4.2173807455819171e-06 4.967834481815248 4.2294815602575073e-06 4.9678343488881431 4.2416462079023897e-06 4.9678342114408993 4.2552178917151882e-06 4.9678340543928172 4.2752898590740079e-06 4.9678338174027585 4.3030154700434212e-06 4.9678334870142216 4.318928752971565e-06 4.9678332984117359 4.333067271853697e-06 4.9678331329660113 4.347144700132333e-06 4.9678329708005409 4.3600587337369687e-06 4.9678328244868242 4.3720864240130112e-06 4.9678326903025098 4.3842143046164423e-06 4.9678325568671546 4.3969058225799655e-06 4.9678324189324208 4.4161107103017454e-06 4.9678322125416283 4.4407523527596054e-06 4.9678319496326377 4.4652059782988082e-06 4.9678316882309188 4.4826029891493775e-06 4.9678315007347562 4.4999999999999468e-06 4.9678313113693209 4.5000999999999809e-06 4.9678313102749936 4.5003000000000491e-06 4.967831308086204 4.5006499999999516e-06 4.9678313042551672 4.5009999999998541e-06 4.9678313004232955 4.5010699999997912e-06 4.9678312996568019 4.5012099999996655e-06 4.96783129812375 4.5012999999999564e-06 4.9678312971381215 4.5014800000005382e-06 4.9678312951666559 4.5018400000017018e-06 4.9678312912232858 4.502560000004029e-06 4.9678312833339016 4.5040000000086833e-06 4.9678312675446143 4.5068800000179921e-06 4.9678312359243284 4.511299999999897e-06 4.9678311872893151 4.5118760000017154e-06 4.9678311809428415 4.5130280000053521e-06 4.9678311682470788 4.5153320000128425e-06 4.9678311428330373 4.5199400000278233e-06 4.967831091905806 4.529156000057568e-06 4.9678309896799968 4.5426197400812596e-06 4.9678308395619659 4.5603257558576426e-06 4.9678306411007886 4.5845911891668166e-06 4.9678303681862435)
V_bus_low_1 bus_low_1 0 PWL(0 0 1.0000000003410059e-10 0 3.0000000010230177e-10 0 6.5000000000481339e-10 0 9.9999999990732502e-10 0 1.0699999998444593e-09 0 1.2099999997187277e-09 0 1.4899999996841051e-09 0 1.99999999981465e-09 0 3.0200000000757399e-09 0 5.0600000005979195e-09 0 9.1400000016422789e-09 0 1.7300000003730998e-08 0 3.3620000007908435e-08 0 6.626000001626331e-08 0 1.1626000001618321e-07 0 1.6626000001610311e-07 0 2.1626000001602301e-07 0 2.6626000001594291e-07 0 3.1626000001586281e-07 0 3.6626000001578271e-07 0 4.1626000001570261e-07 0 4.5813000000777607e-07 0 4.9999999999984952e-07 0 5.0009999999988362e-07 0 5.0029999999995182e-07 0 5.0064999999985434e-07 0 5.0099999999975685e-07 0 5.0106999999969398e-07 0 5.0120999999956825e-07 0 5.0129999999985915e-07 0 5.0148000000044095e-07 0 5.0184000000160454e-07 0 5.0256000000393174e-07 0 5.0400000000858612e-07 0 5.0688000001789489e-07 0 5.1264000003651243e-07 0 5.2416000007374751e-07 0 5.4720000014821767e-07 0 5.9328000029715798e-07 0 6.4328000029707788e-07 0 6.9328000029699778e-07 0 7.4328000029691768e-07 0 7.9328000029683758e-07 0 8.4328000029675748e-07 0 8.9328000029667738e-07 0 9.4328000029659728e-07 0 9.7164000014814816e-07 0 9.9999999999991589e-07 0 1.00009999999995e-06 0 1.0003000000000182e-06 0 1.0006499999999207e-06 0 1.0009999999998232e-06 0 1.0010699999997603e-06 0 1.0012099999996346e-06 0 1.0014899999996e-06 0 1.0019999999997305e-06 0 1.0030199999999916e-06 0 1.0050600000005138e-06 0 1.0091400000015582e-06 0 1.0173000000036469e-06 0 1.0336200000078243e-06 0 1.0662600000161792e-06 0 1.1162600000160991e-06 0 1.166260000016019e-06 0 1.2162600000159389e-06 0 1.2662600000158588e-06 0 1.3162600000157787e-06 0 1.3662600000156986e-06 0 1.4162600000156185e-06 0 1.458130000007692e-06 0 1.4999999999997654e-06 0 1.5049999999997357e-06 0 1.505999999999643e-06 0 1.5079999999994577e-06 0 1.511999999999087e-06 0 1.5199999999983456e-06 0 1.5359999999968628e-06 0 1.5679999999938972e-06 0 1.6179999999938171e-06 0 1.667999999993737e-06 0 1.7179999999936569e-06 0 1.7679999999935768e-06 0 1.8179999999934967e-06 0 1.8679999999934166e-06 0 1.9179999999933365e-06 0 1.9589999999966926e-06 0 2.0000000000000486e-06 0 2.0001000000000827e-06 0 2.0003000000001509e-06 0 2.0006500000000534e-06 0 2.0009999999999559e-06 0 2.0010699999998931e-06 0 2.0012099999997673e-06 0 2.0014899999997327e-06 0 2.0019999999998633e-06 0 2.0030200000001244e-06 0 2.0050600000006465e-06 0 2.0091400000016909e-06 0 2.0173000000037796e-06 0 2.033620000007957e-06 0 2.0662600000163119e-06 0 2.1162600000162318e-06 0 2.1662600000161517e-06 0 2.2162600000160716e-06 0 2.2662600000159915e-06 0 2.3162600000159114e-06 0 2.3662600000158313e-06 0 2.4162600000157512e-06 0 2.4581300000078247e-06 0 2.4999999999998981e-06 0 2.5000999999999322e-06 0 2.5003000000000004e-06 0 2.500649999999903e-06 0 2.5009999999998055e-06 0 2.5010699999997426e-06 0 2.5012099999996169e-06 0 2.5012999999999078e-06 0 2.5014800000004896e-06 0 2.5018400000016532e-06 0 2.5025600000039804e-06 0 2.5040000000086347e-06 0 2.5068800000179435e-06 0 2.5112999999998484e-06 0 2.5118760000016668e-06 0 2.5130280000053035e-06 0 2.5153320000127939e-06 0 2.5199400000277747e-06 0 2.5291560000575194e-06 0 2.5475880001170088e-06 0 2.5844520002362044e-06 0 2.6344520002361243e-06 0 2.6844520002360442e-06 0 2.7344520002359641e-06 0 2.784452000235884e-06 0 2.8344520002358039e-06 0 2.8844520002357238e-06 0 2.9344520002356437e-06 0 2.9672260001179125e-06 0 2.9999999999999645e-06 0 3.0000999999999986e-06 0 3.0003000000000668e-06 0 3.0006499999999693e-06 0 3.0009999999998718e-06 0 3.001069999999809e-06 0 3.0012099999996832e-06 0 3.0014899999996486e-06 0 3.0019999999997792e-06 0 3.0030200000000402e-06 0 3.0050600000005624e-06 0 3.0091400000016068e-06 0 3.0119999999997198e-06 0 3.0120073520312467e-06 0 3.0120220560943007e-06 0 3.0120514642204086e-06 0 3.0121102804726244e-06 0 3.0122279129770561e-06 0 3.0124631779861362e-06 0 3.0129337080042964e-06 0 3.0132348686766515e-06 0 3.0135914349197629e-06 0 3.0139627095852883e-06 0 3.0147052589163392e-06 0 3.016190357578441e-06 0 3.0183097521391169e-06 0 3.0184068898265505e-06 0 3.0186011652014177e-06 0 3.0189897159513691e-06 0 3.0193097521390242e-06 0 3.0194840032100618e-06 0 3.0198325053523538e-06 0 3.0205295096369378e-06 0 3.0219235182061058e-06 0 3.0241116967082149e-06 0 3.0242086352097117e-06 0 3.0244025122124884e-06 0 3.0247902662180418e-06 0 3.0251116967081222e-06 0 3.0252852672042058e-06 0 3.0256324081963729e-06 0 3.0263266901804902e-06 0 3.0277152541489417e-06 0 3.029907747478626e-06 0 3.0323934483297236e-06 0 3.0346461047591703e-06 0 3.0368579413645336e-06 0 3.0390221428943254e-06 0 3.0412547698324688e-06 0 3.0434585961314382e-06 0 3.0456899269559745e-06 0 3.0478921795146739e-06 0 3.0501161559816359e-06 0 3.0502129813563938e-06 0 3.0504066321059096e-06 0 3.050793933605158e-06 0 3.0511161559815432e-06 0 3.0512893425711785e-06 0 3.0516357157506658e-06 0 3.0523284621094236e-06 0 3.0537139548269393e-06 0 3.0559088928521112e-06 0 3.0583929601468544e-06 0 3.0606472216664939e-06 0 3.0611161559814838e-06 0 3.0613372026418433e-06 0 3.0613920063930072e-06 0 3.0614879129573815e-06 0 3.0615144585243413e-06 0 3.0615609132665211e-06 0 3.0615737712754495e-06 0 3.0615962727915079e-06 0 3.0616045544249165e-06 0 3.0616098677673474e-06 0 3.0616129118197707e-06 0 3.061614691158383e-06 0 3.061615727424508e-06 0 3.0616164009239586e-06 0 3.0616170327904795e-06 0 3.0616175295513151e-06 0 3.0616181141201668e-06 0 3.0616192832576532e-06 0 3.061621621532843e-06 0 3.0616262980832226e-06 0 3.0616356511839818e-06 0 3.0616543573855001e-06 0 3.0616917697885368e-06 0 3.0617665945946101e-06 0 3.0619162442067568e-06 0 3.0622155434308334e-06 0 3.0628141418792033e-06 0 3.0640113387759432e-06 0 3.0664057325692062e-06 0 3.0691268298945352e-06 0 3.0722518989335836e-06 0 3.0755930962055641e-06 0 3.0797431498758542e-06 0 3.0846132153682267e-06 0 3.0909839668516546e-06 0 3.0990912256400032e-06 0 3.1109055103721583e-06 0 3.1199775501265618e-06 0 3.1209775501264692e-06 0 3.1219510434603737e-06 0 3.123898030127966e-06 0 3.1277920034631507e-06 0 3.128792003463058e-06 0 3.1298847767947339e-06 0 3.1309775501264098e-06 0 3.1311961047927449e-06 0 3.1316332141254153e-06 0 3.132507432790756e-06 0 3.1342558701214374e-06 0 3.1377527447828003e-06 0 3.1447464941055259e-06 0 3.1570238457376103e-06 0 3.169967668616375e-06 0 3.1792744972648345e-06 0 3.1880261083733815e-06 0 3.1968863574336447e-06 0 3.2083031602789854e-06 0 3.2220961031015957e-06 0 3.2314900035761498e-06 0 3.2404165366069129e-06 0 3.2494156640850563e-06 0 3.2612424525238319e-06 0 3.2737456763902439e-06 0 3.2846521856703687e-06 0 3.2945975668686404e-06 0 3.3046574861731251e-06 0 3.3152066651748191e-06 0 3.3303558952639534e-06 0 3.3437543430208262e-06 0 3.3539459505889033e-06 0 3.3641136639650168e-06 0 3.3743154896168515e-06 0 3.3869655327685086e-06 0 3.4044499062661424e-06 0 3.4211022211468912e-06 0 3.4355727319176476e-06 0 3.4485631791891271e-06 0 3.4610935139738671e-06 0 3.4735426313870204e-06 0 3.4867713156934172e-06 0 3.4933856578466156e-06 0 3.499999999999814e-06 0 3.5005983760835226e-06 0 3.5009999999999382e-06 0 3.5011196752167233e-06 0 3.5013590256500766e-06 0 3.5015983760834299e-06 0 3.5020770769501365e-06 0 3.5030344786835498e-06 0 3.5049492821503762e-06 0 3.5087788890840292e-06 0 3.5164381029513352e-06 0 3.5263212535476419e-06 0 3.5366371995170561e-06 0 3.5470283681060533e-06 0 3.5591078799636269e-06 0 3.5749257219813875e-06 0 3.5938740270806142e-06 0 3.6103909770127292e-06 0 3.624105672399465e-06 0 3.6362934308278166e-06 0 3.6490725321414175e-06 0 3.6605790223616895e-06 0 3.6731371480557603e-06 0 3.6907685852015457e-06 0 3.7137126618050267e-06 0 3.7344122790518557e-06 0 3.7514968602573358e-06 0 3.7659442756333549e-06 0 3.7783546281034298e-06 0 3.789912918107782e-06 0 3.8015502303375293e-06 0 3.8138771296047057e-06 0 3.8323647086728214e-06 0 3.8568359771468802e-06 0 3.8780099450427472e-06 0 3.8938022094603571e-06 0 3.9079113781151625e-06 0 3.9210317374111393e-06 0 3.9329965694668168e-06 0 3.9453808124334435e-06 0 3.9579144787134195e-06 0 3.9752330372180237e-06 0 3.9876165186091689e-06 0 4.0000000000000972e-06 0 4.0001000000001313e-06 0 4.0003000000001995e-06 0 4.000650000000102e-06 0 4.0010000000000046e-06 0 4.0010699999999417e-06 0 4.001209999999816e-06 0 4.0014899999997813e-06 0 4.0019999999999119e-06 0 4.003020000000173e-06 0 4.0050600000006951e-06 0 4.0091400000017395e-06 0 4.0173000000038282e-06 0 4.0336200000080057e-06 0 4.0507049849855536e-06 0 4.0647118061357557e-06 0 4.0763612613181621e-06 0 4.0896232236938782e-06 0 4.1017938909330889e-06 0 4.1190755976415559e-06 0 4.1407302293627879e-06 0 4.1605746585030891e-06 0 4.1757842378362716e-06 0 4.1903295049127744e-06 0 4.204670839506831e-06 0 4.2173807455819171e-06 0 4.2294815602575073e-06 0 4.2416462079023897e-06 0 4.2552178917151882e-06 0 4.2752898590740079e-06 0 4.3030154700434212e-06 0 4.318928752971565e-06 0 4.333067271853697e-06 0 4.347144700132333e-06 0 4.3600587337369687e-06 0 4.3720864240130112e-06 0 4.3842143046164423e-06 0 4.3969058225799655e-06 0 4.4161107103017454e-06 0 4.4407523527596054e-06 0 4.4652059782988082e-06 0 4.4826029891493775e-06 0 4.4999999999999468e-06 0 4.5000999999999809e-06 0 4.5003000000000491e-06 0 4.5006499999999516e-06 0 4.5009999999998541e-06 0 4.5010699999997912e-06 0 4.5012099999996655e-06 0 4.5012999999999564e-06 0 4.5014800000005382e-06 0 4.5018400000017018e-06 0 4.502560000004029e-06 0 4.5040000000086833e-06 0 4.5068800000179921e-06 0 4.511299999999897e-06 0 4.5118760000017154e-06 0 4.5130280000053521e-06 0 4.5153320000128425e-06 0 4.5199400000278233e-06 0 4.529156000057568e-06 0 4.5426197400812596e-06 0 4.5603257558576426e-06 0 4.5845911891668166e-06 0)
V_bus_high_1 bus_high_1 0 PWL(0 0 1.0000000003410059e-10 0 3.0000000010230177e-10 0 6.5000000000481339e-10 0 9.9999999990732502e-10 0 1.0699999998444593e-09 0 1.2099999997187277e-09 0 1.4899999996841051e-09 0 1.99999999981465e-09 0 3.0200000000757399e-09 0 5.0600000005979195e-09 0 9.1400000016422789e-09 0 1.7300000003730998e-08 0 3.3620000007908435e-08 0 6.626000001626331e-08 0 1.1626000001618321e-07 0 1.6626000001610311e-07 0 2.1626000001602301e-07 0 2.6626000001594291e-07 0 3.1626000001586281e-07 0 3.6626000001578271e-07 0 4.1626000001570261e-07 0 4.5813000000777607e-07 0 4.9999999999984952e-07 0 5.0009999999988362e-07 0 5.0029999999995182e-07 0 5.0064999999985434e-07 0 5.0099999999975685e-07 0 5.0106999999969398e-07 0 5.0120999999956825e-07 0 5.0129999999985915e-07 0 5.0148000000044095e-07 0 5.0184000000160454e-07 0 5.0256000000393174e-07 0 5.0400000000858612e-07 0 5.0688000001789489e-07 0 5.1264000003651243e-07 0 5.2416000007374751e-07 0 5.4720000014821767e-07 0 5.9328000029715798e-07 0 6.4328000029707788e-07 0 6.9328000029699778e-07 0 7.4328000029691768e-07 0 7.9328000029683758e-07 0 8.4328000029675748e-07 0 8.9328000029667738e-07 0 9.4328000029659728e-07 0 9.7164000014814816e-07 0 9.9999999999991589e-07 0 1.00009999999995e-06 0 1.0003000000000182e-06 0 1.0006499999999207e-06 0 1.0009999999998232e-06 0 1.0010699999997603e-06 0 1.0012099999996346e-06 0 1.0014899999996e-06 0 1.0019999999997305e-06 0 1.0030199999999916e-06 0 1.0050600000005138e-06 0 1.0091400000015582e-06 0 1.0173000000036469e-06 0 1.0336200000078243e-06 0 1.0662600000161792e-06 0 1.1162600000160991e-06 0 1.166260000016019e-06 0 1.2162600000159389e-06 0 1.2662600000158588e-06 0 1.3162600000157787e-06 0 1.3662600000156986e-06 0 1.4162600000156185e-06 0 1.458130000007692e-06 0 1.4999999999997654e-06 0 1.5049999999997357e-06 0 1.505999999999643e-06 0 1.5079999999994577e-06 0 1.511999999999087e-06 0 1.5199999999983456e-06 0 1.5359999999968628e-06 0 1.5679999999938972e-06 0 1.6179999999938171e-06 0 1.667999999993737e-06 0 1.7179999999936569e-06 0 1.7679999999935768e-06 0 1.8179999999934967e-06 0 1.8679999999934166e-06 0 1.9179999999933365e-06 0 1.9589999999966926e-06 0 2.0000000000000486e-06 0 2.0001000000000827e-06 0 2.0003000000001509e-06 0 2.0006500000000534e-06 0 2.0009999999999559e-06 0 2.0010699999998931e-06 0 2.0012099999997673e-06 0 2.0014899999997327e-06 0 2.0019999999998633e-06 0 2.0030200000001244e-06 0 2.0050600000006465e-06 0 2.0091400000016909e-06 0 2.0173000000037796e-06 0 2.033620000007957e-06 0 2.0662600000163119e-06 0 2.1162600000162318e-06 0 2.1662600000161517e-06 0 2.2162600000160716e-06 0 2.2662600000159915e-06 0 2.3162600000159114e-06 0 2.3662600000158313e-06 0 2.4162600000157512e-06 0 2.4581300000078247e-06 0 2.4999999999998981e-06 0 2.5000999999999322e-06 0 2.5003000000000004e-06 0 2.500649999999903e-06 0 2.5009999999998055e-06 0 2.5010699999997426e-06 0 2.5012099999996169e-06 0 2.5012999999999078e-06 0 2.5014800000004896e-06 0 2.5018400000016532e-06 0 2.5025600000039804e-06 0 2.5040000000086347e-06 0 2.5068800000179435e-06 0 2.5112999999998484e-06 0 2.5118760000016668e-06 0 2.5130280000053035e-06 0 2.5153320000127939e-06 0 2.5199400000277747e-06 0 2.5291560000575194e-06 0 2.5475880001170088e-06 0 2.5844520002362044e-06 0 2.6344520002361243e-06 0 2.6844520002360442e-06 0 2.7344520002359641e-06 0 2.784452000235884e-06 0 2.8344520002358039e-06 0 2.8844520002357238e-06 0 2.9344520002356437e-06 0 2.9672260001179125e-06 0 2.9999999999999645e-06 0 3.0000999999999986e-06 0 3.0003000000000668e-06 0 3.0006499999999693e-06 0 3.0009999999998718e-06 0 3.001069999999809e-06 0 3.0012099999996832e-06 0 3.0014899999996486e-06 0 3.0019999999997792e-06 0 3.0030200000000402e-06 0 3.0050600000005624e-06 0 3.0091400000016068e-06 0 3.0119999999997198e-06 0 3.0120073520312467e-06 0 3.0120220560943007e-06 0 3.0120514642204086e-06 0 3.0121102804726244e-06 0 3.0122279129770561e-06 0 3.0124631779861362e-06 0 3.0129337080042964e-06 0 3.0132348686766515e-06 0 3.0135914349197629e-06 0 3.0139627095852883e-06 0 3.0147052589163392e-06 0 3.016190357578441e-06 0 3.0183097521391169e-06 0 3.0184068898265505e-06 0 3.0186011652014177e-06 0 3.0189897159513691e-06 0 3.0193097521390242e-06 0 3.0194840032100618e-06 0 3.0198325053523538e-06 0 3.0205295096369378e-06 0 3.0219235182061058e-06 0 3.0241116967082149e-06 0 3.0242086352097117e-06 0 3.0244025122124884e-06 0 3.0247902662180418e-06 0 3.0251116967081222e-06 0 3.0252852672042058e-06 0 3.0256324081963729e-06 0 3.0263266901804902e-06 0 3.0277152541489417e-06 0 3.029907747478626e-06 0 3.0323934483297236e-06 0 3.0346461047591703e-06 0 3.0368579413645336e-06 0 3.0390221428943254e-06 0 3.0412547698324688e-06 0 3.0434585961314382e-06 0 3.0456899269559745e-06 0 3.0478921795146739e-06 0 3.0501161559816359e-06 0 3.0502129813563938e-06 0 3.0504066321059096e-06 0 3.050793933605158e-06 0 3.0511161559815432e-06 0 3.0512893425711785e-06 0 3.0516357157506658e-06 0 3.0523284621094236e-06 0 3.0537139548269393e-06 0 3.0559088928521112e-06 0 3.0583929601468544e-06 0 3.0606472216664939e-06 0 3.0611161559814838e-06 0 3.0613372026418433e-06 0 3.0613920063930072e-06 0 3.0614879129573815e-06 0 3.0615144585243413e-06 0 3.0615609132665211e-06 0 3.0615737712754495e-06 0 3.0615962727915079e-06 0 3.0616045544249165e-06 0 3.0616098677673474e-06 0 3.0616129118197707e-06 0 3.061614691158383e-06 0 3.061615727424508e-06 0 3.0616164009239586e-06 0 3.0616170327904795e-06 0 3.0616175295513151e-06 0 3.0616181141201668e-06 0 3.0616192832576532e-06 0 3.061621621532843e-06 0 3.0616262980832226e-06 0 3.0616356511839818e-06 0 3.0616543573855001e-06 0 3.0616917697885368e-06 0 3.0617665945946101e-06 0 3.0619162442067568e-06 0 3.0622155434308334e-06 0 3.0628141418792033e-06 0 3.0640113387759432e-06 0 3.0664057325692062e-06 0 3.0691268298945352e-06 0 3.0722518989335836e-06 0 3.0755930962055641e-06 0 3.0797431498758542e-06 0 3.0846132153682267e-06 0 3.0909839668516546e-06 0 3.0990912256400032e-06 0 3.1109055103721583e-06 0 3.1199775501265618e-06 0 3.1209775501264692e-06 0 3.1219510434603737e-06 0 3.123898030127966e-06 0 3.1277920034631507e-06 0 3.128792003463058e-06 0 3.1298847767947339e-06 0 3.1309775501264098e-06 0 3.1311961047927449e-06 0 3.1316332141254153e-06 0 3.132507432790756e-06 0 3.1342558701214374e-06 0 3.1377527447828003e-06 0 3.1447464941055259e-06 0 3.1570238457376103e-06 0 3.169967668616375e-06 0 3.1792744972648345e-06 0 3.1880261083733815e-06 0 3.1968863574336447e-06 0 3.2083031602789854e-06 0 3.2220961031015957e-06 0 3.2314900035761498e-06 0 3.2404165366069129e-06 0 3.2494156640850563e-06 0 3.2612424525238319e-06 0 3.2737456763902439e-06 0 3.2846521856703687e-06 0 3.2945975668686404e-06 0 3.3046574861731251e-06 0 3.3152066651748191e-06 0 3.3303558952639534e-06 0 3.3437543430208262e-06 0 3.3539459505889033e-06 0 3.3641136639650168e-06 0 3.3743154896168515e-06 0 3.3869655327685086e-06 0 3.4044499062661424e-06 0 3.4211022211468912e-06 0 3.4355727319176476e-06 0 3.4485631791891271e-06 0 3.4610935139738671e-06 0 3.4735426313870204e-06 0 3.4867713156934172e-06 0 3.4933856578466156e-06 0 3.499999999999814e-06 0 3.5005983760835226e-06 0 3.5009999999999382e-06 0 3.5011196752167233e-06 0 3.5013590256500766e-06 0 3.5015983760834299e-06 0 3.5020770769501365e-06 0 3.5030344786835498e-06 0 3.5049492821503762e-06 0 3.5087788890840292e-06 0 3.5164381029513352e-06 0 3.5263212535476419e-06 0 3.5366371995170561e-06 0 3.5470283681060533e-06 0 3.5591078799636269e-06 0 3.5749257219813875e-06 0 3.5938740270806142e-06 0 3.6103909770127292e-06 0 3.624105672399465e-06 0 3.6362934308278166e-06 0 3.6490725321414175e-06 0 3.6605790223616895e-06 0 3.6731371480557603e-06 0 3.6907685852015457e-06 0 3.7137126618050267e-06 0 3.7344122790518557e-06 0 3.7514968602573358e-06 0 3.7659442756333549e-06 0 3.7783546281034298e-06 0 3.789912918107782e-06 0 3.8015502303375293e-06 0 3.8138771296047057e-06 0 3.8323647086728214e-06 0 3.8568359771468802e-06 0 3.8780099450427472e-06 0 3.8938022094603571e-06 0 3.9079113781151625e-06 0 3.9210317374111393e-06 0 3.9329965694668168e-06 0 3.9453808124334435e-06 0 3.9579144787134195e-06 0 3.9752330372180237e-06 0 3.9876165186091689e-06 0 4.0000000000000972e-06 0 4.0001000000001313e-06 0 4.0003000000001995e-06 0 4.000650000000102e-06 0 4.0010000000000046e-06 0 4.0010699999999417e-06 0 4.001209999999816e-06 0 4.0014899999997813e-06 0 4.0019999999999119e-06 0 4.003020000000173e-06 0 4.0050600000006951e-06 0 4.0091400000017395e-06 0 4.0173000000038282e-06 0 4.0336200000080057e-06 0 4.0507049849855536e-06 0 4.0647118061357557e-06 0 4.0763612613181621e-06 0 4.0896232236938782e-06 0 4.1017938909330889e-06 0 4.1190755976415559e-06 0 4.1407302293627879e-06 0 4.1605746585030891e-06 0 4.1757842378362716e-06 0 4.1903295049127744e-06 0 4.204670839506831e-06 0 4.2173807455819171e-06 0 4.2294815602575073e-06 0 4.2416462079023897e-06 0 4.2552178917151882e-06 0 4.2752898590740079e-06 0 4.3030154700434212e-06 0 4.318928752971565e-06 0 4.333067271853697e-06 0 4.347144700132333e-06 0 4.3600587337369687e-06 0 4.3720864240130112e-06 0 4.3842143046164423e-06 0 4.3969058225799655e-06 0 4.4161107103017454e-06 0 4.4407523527596054e-06 0 4.4652059782988082e-06 0 4.4826029891493775e-06 0 4.4999999999999468e-06 0 4.5000999999999809e-06 0 4.5003000000000491e-06 0 4.5006499999999516e-06 0 4.5009999999998541e-06 0 4.5010699999997912e-06 0 4.5012099999996655e-06 0 4.5012999999999564e-06 0 4.5014800000005382e-06 0 4.5018400000017018e-06 0 4.502560000004029e-06 0 4.5040000000086833e-06 0 4.5068800000179921e-06 0 4.511299999999897e-06 0 4.5118760000017154e-06 0 4.5130280000053521e-06 0 4.5153320000128425e-06 0 4.5199400000278233e-06 0 4.529156000057568e-06 0 4.5426197400812596e-06 0 4.5603257558576426e-06 0 4.5845911891668166e-06 0)
V_bus_low_9 bus_low_9 0 PWL(0 0 1.0000000003410059e-10 0 3.0000000010230177e-10 0 6.5000000000481339e-10 0 9.9999999990732502e-10 0 1.0699999998444593e-09 0 1.2099999997187277e-09 0 1.4899999996841051e-09 0 1.99999999981465e-09 0 3.0200000000757399e-09 0 5.0600000005979195e-09 0 9.1400000016422789e-09 0 1.7300000003730998e-08 0 3.3620000007908435e-08 0 6.626000001626331e-08 0 1.1626000001618321e-07 0 1.6626000001610311e-07 0 2.1626000001602301e-07 0 2.6626000001594291e-07 0 3.1626000001586281e-07 0 3.6626000001578271e-07 0 4.1626000001570261e-07 0 4.5813000000777607e-07 0 4.9999999999984952e-07 0 5.0009999999988362e-07 0 5.0029999999995182e-07 0 5.0064999999985434e-07 0 5.0099999999975685e-07 0 5.0106999999969398e-07 0 5.0120999999956825e-07 0 5.0129999999985915e-07 0 5.0148000000044095e-07 0 5.0184000000160454e-07 0 5.0256000000393174e-07 0 5.0400000000858612e-07 0 5.0688000001789489e-07 0 5.1264000003651243e-07 0 5.2416000007374751e-07 0 5.4720000014821767e-07 0 5.9328000029715798e-07 0 6.4328000029707788e-07 0 6.9328000029699778e-07 0 7.4328000029691768e-07 0 7.9328000029683758e-07 0 8.4328000029675748e-07 0 8.9328000029667738e-07 0 9.4328000029659728e-07 0 9.7164000014814816e-07 0 9.9999999999991589e-07 0 1.00009999999995e-06 0 1.0003000000000182e-06 0 1.0006499999999207e-06 0 1.0009999999998232e-06 0 1.0010699999997603e-06 0 1.0012099999996346e-06 0 1.0014899999996e-06 0 1.0019999999997305e-06 0 1.0030199999999916e-06 0 1.0050600000005138e-06 0 1.0091400000015582e-06 0 1.0173000000036469e-06 0 1.0336200000078243e-06 0 1.0662600000161792e-06 0 1.1162600000160991e-06 0 1.166260000016019e-06 0 1.2162600000159389e-06 0 1.2662600000158588e-06 0 1.3162600000157787e-06 0 1.3662600000156986e-06 0 1.4162600000156185e-06 0 1.458130000007692e-06 0 1.4999999999997654e-06 0 1.5049999999997357e-06 0 1.505999999999643e-06 0 1.5079999999994577e-06 0 1.511999999999087e-06 0 1.5199999999983456e-06 0 1.5359999999968628e-06 0 1.5679999999938972e-06 0 1.6179999999938171e-06 0 1.667999999993737e-06 0 1.7179999999936569e-06 0 1.7679999999935768e-06 0 1.8179999999934967e-06 0 1.8679999999934166e-06 0 1.9179999999933365e-06 0 1.9589999999966926e-06 0 2.0000000000000486e-06 0 2.0001000000000827e-06 0 2.0003000000001509e-06 0 2.0006500000000534e-06 0 2.0009999999999559e-06 0 2.0010699999998931e-06 0 2.0012099999997673e-06 0 2.0014899999997327e-06 0 2.0019999999998633e-06 0 2.0030200000001244e-06 0 2.0050600000006465e-06 0 2.0091400000016909e-06 0 2.0173000000037796e-06 0 2.033620000007957e-06 0 2.0662600000163119e-06 0 2.1162600000162318e-06 0 2.1662600000161517e-06 0 2.2162600000160716e-06 0 2.2662600000159915e-06 0 2.3162600000159114e-06 0 2.3662600000158313e-06 0 2.4162600000157512e-06 0 2.4581300000078247e-06 0 2.4999999999998981e-06 0 2.5000999999999322e-06 0 2.5003000000000004e-06 0 2.500649999999903e-06 0 2.5009999999998055e-06 0 2.5010699999997426e-06 0 2.5012099999996169e-06 0 2.5012999999999078e-06 0 2.5014800000004896e-06 0 2.5018400000016532e-06 0 2.5025600000039804e-06 0 2.5040000000086347e-06 0 2.5068800000179435e-06 0 2.5112999999998484e-06 0 2.5118760000016668e-06 0 2.5130280000053035e-06 0 2.5153320000127939e-06 0 2.5199400000277747e-06 0 2.5291560000575194e-06 0 2.5475880001170088e-06 0 2.5844520002362044e-06 0 2.6344520002361243e-06 0 2.6844520002360442e-06 0 2.7344520002359641e-06 0 2.784452000235884e-06 0 2.8344520002358039e-06 0 2.8844520002357238e-06 0 2.9344520002356437e-06 0 2.9672260001179125e-06 0 2.9999999999999645e-06 0 3.0000999999999986e-06 0 3.0003000000000668e-06 0 3.0006499999999693e-06 0 3.0009999999998718e-06 0 3.001069999999809e-06 0 3.0012099999996832e-06 0 3.0014899999996486e-06 0 3.0019999999997792e-06 0 3.0030200000000402e-06 0 3.0050600000005624e-06 0 3.0091400000016068e-06 0 3.0119999999997198e-06 0 3.0120073520312467e-06 0 3.0120220560943007e-06 0 3.0120514642204086e-06 0 3.0121102804726244e-06 0 3.0122279129770561e-06 0 3.0124631779861362e-06 0 3.0129337080042964e-06 0 3.0132348686766515e-06 0 3.0135914349197629e-06 0 3.0139627095852883e-06 0 3.0147052589163392e-06 0 3.016190357578441e-06 0 3.0183097521391169e-06 0 3.0184068898265505e-06 0 3.0186011652014177e-06 0 3.0189897159513691e-06 0 3.0193097521390242e-06 0 3.0194840032100618e-06 0 3.0198325053523538e-06 0 3.0205295096369378e-06 0 3.0219235182061058e-06 0 3.0241116967082149e-06 0 3.0242086352097117e-06 0 3.0244025122124884e-06 0 3.0247902662180418e-06 0 3.0251116967081222e-06 0 3.0252852672042058e-06 0 3.0256324081963729e-06 0 3.0263266901804902e-06 0 3.0277152541489417e-06 0 3.029907747478626e-06 0 3.0323934483297236e-06 0 3.0346461047591703e-06 0 3.0368579413645336e-06 0 3.0390221428943254e-06 0 3.0412547698324688e-06 0 3.0434585961314382e-06 0 3.0456899269559745e-06 0 3.0478921795146739e-06 0 3.0501161559816359e-06 0 3.0502129813563938e-06 0 3.0504066321059096e-06 0 3.050793933605158e-06 0 3.0511161559815432e-06 0 3.0512893425711785e-06 0 3.0516357157506658e-06 0 3.0523284621094236e-06 0 3.0537139548269393e-06 0 3.0559088928521112e-06 0 3.0583929601468544e-06 0 3.0606472216664939e-06 0 3.0611161559814838e-06 0 3.0613372026418433e-06 0 3.0613920063930072e-06 0 3.0614879129573815e-06 0 3.0615144585243413e-06 0 3.0615609132665211e-06 0 3.0615737712754495e-06 0 3.0615962727915079e-06 0 3.0616045544249165e-06 0 3.0616098677673474e-06 0 3.0616129118197707e-06 0 3.061614691158383e-06 0 3.061615727424508e-06 0 3.0616164009239586e-06 0 3.0616170327904795e-06 0 3.0616175295513151e-06 0 3.0616181141201668e-06 0 3.0616192832576532e-06 0 3.061621621532843e-06 0 3.0616262980832226e-06 0 3.0616356511839818e-06 0 3.0616543573855001e-06 0 3.0616917697885368e-06 0 3.0617665945946101e-06 0 3.0619162442067568e-06 0 3.0622155434308334e-06 0 3.0628141418792033e-06 0 3.0640113387759432e-06 0 3.0664057325692062e-06 0 3.0691268298945352e-06 0 3.0722518989335836e-06 0 3.0755930962055641e-06 0 3.0797431498758542e-06 0 3.0846132153682267e-06 0 3.0909839668516546e-06 0 3.0990912256400032e-06 0 3.1109055103721583e-06 0 3.1199775501265618e-06 0 3.1209775501264692e-06 0 3.1219510434603737e-06 0 3.123898030127966e-06 0 3.1277920034631507e-06 0 3.128792003463058e-06 0 3.1298847767947339e-06 0 3.1309775501264098e-06 0 3.1311961047927449e-06 0 3.1316332141254153e-06 0 3.132507432790756e-06 0 3.1342558701214374e-06 0 3.1377527447828003e-06 0 3.1447464941055259e-06 0 3.1570238457376103e-06 0 3.169967668616375e-06 0 3.1792744972648345e-06 0 3.1880261083733815e-06 0 3.1968863574336447e-06 0 3.2083031602789854e-06 0 3.2220961031015957e-06 0 3.2314900035761498e-06 0 3.2404165366069129e-06 0 3.2494156640850563e-06 0 3.2612424525238319e-06 0 3.2737456763902439e-06 0 3.2846521856703687e-06 0 3.2945975668686404e-06 0 3.3046574861731251e-06 0 3.3152066651748191e-06 0 3.3303558952639534e-06 0 3.3437543430208262e-06 0 3.3539459505889033e-06 0 3.3641136639650168e-06 0 3.3743154896168515e-06 0 3.3869655327685086e-06 0 3.4044499062661424e-06 0 3.4211022211468912e-06 0 3.4355727319176476e-06 0 3.4485631791891271e-06 0 3.4610935139738671e-06 0 3.4735426313870204e-06 0 3.4867713156934172e-06 0 3.4933856578466156e-06 0 3.499999999999814e-06 0 3.5005983760835226e-06 0 3.5009999999999382e-06 0 3.5011196752167233e-06 0 3.5013590256500766e-06 0 3.5015983760834299e-06 0 3.5020770769501365e-06 0 3.5030344786835498e-06 0 3.5049492821503762e-06 0 3.5087788890840292e-06 0 3.5164381029513352e-06 0 3.5263212535476419e-06 0 3.5366371995170561e-06 0 3.5470283681060533e-06 0 3.5591078799636269e-06 0 3.5749257219813875e-06 0 3.5938740270806142e-06 0 3.6103909770127292e-06 0 3.624105672399465e-06 0 3.6362934308278166e-06 0 3.6490725321414175e-06 0 3.6605790223616895e-06 0 3.6731371480557603e-06 0 3.6907685852015457e-06 0 3.7137126618050267e-06 0 3.7344122790518557e-06 0 3.7514968602573358e-06 0 3.7659442756333549e-06 0 3.7783546281034298e-06 0 3.789912918107782e-06 0 3.8015502303375293e-06 0 3.8138771296047057e-06 0 3.8323647086728214e-06 0 3.8568359771468802e-06 0 3.8780099450427472e-06 0 3.8938022094603571e-06 0 3.9079113781151625e-06 0 3.9210317374111393e-06 0 3.9329965694668168e-06 0 3.9453808124334435e-06 0 3.9579144787134195e-06 0 3.9752330372180237e-06 0 3.9876165186091689e-06 0 4.0000000000000972e-06 0 4.0001000000001313e-06 0 4.0003000000001995e-06 0 4.000650000000102e-06 0 4.0010000000000046e-06 0 4.0010699999999417e-06 0 4.001209999999816e-06 0 4.0014899999997813e-06 0 4.0019999999999119e-06 0 4.003020000000173e-06 0 4.0050600000006951e-06 0 4.0091400000017395e-06 0 4.0173000000038282e-06 0 4.0336200000080057e-06 0 4.0507049849855536e-06 0 4.0647118061357557e-06 0 4.0763612613181621e-06 0 4.0896232236938782e-06 0 4.1017938909330889e-06 0 4.1190755976415559e-06 0 4.1407302293627879e-06 0 4.1605746585030891e-06 0 4.1757842378362716e-06 0 4.1903295049127744e-06 0 4.204670839506831e-06 0 4.2173807455819171e-06 0 4.2294815602575073e-06 0 4.2416462079023897e-06 0 4.2552178917151882e-06 0 4.2752898590740079e-06 0 4.3030154700434212e-06 0 4.318928752971565e-06 0 4.333067271853697e-06 0 4.347144700132333e-06 0 4.3600587337369687e-06 0 4.3720864240130112e-06 0 4.3842143046164423e-06 0 4.3969058225799655e-06 0 4.4161107103017454e-06 0 4.4407523527596054e-06 0 4.4652059782988082e-06 0 4.4826029891493775e-06 0 4.4999999999999468e-06 0 4.5000999999999809e-06 0 4.5003000000000491e-06 0 4.5006499999999516e-06 0 4.5009999999998541e-06 0 4.5010699999997912e-06 0 4.5012099999996655e-06 0 4.5012999999999564e-06 0 4.5014800000005382e-06 0 4.5018400000017018e-06 0 4.502560000004029e-06 0 4.5040000000086833e-06 0 4.5068800000179921e-06 0 4.511299999999897e-06 0 4.5118760000017154e-06 0 4.5130280000053521e-06 0 4.5153320000128425e-06 0 4.5199400000278233e-06 0 4.529156000057568e-06 0 4.5426197400812596e-06 0 4.5603257558576426e-06 0 4.5845911891668166e-06 0)
V_bus_high_9 bus_high_9 0 PWL(0 0 1.0000000003410059e-10 0 3.0000000010230177e-10 0 6.5000000000481339e-10 0 9.9999999990732502e-10 0 1.0699999998444593e-09 0 1.2099999997187277e-09 0 1.4899999996841051e-09 0 1.99999999981465e-09 0 3.0200000000757399e-09 0 5.0600000005979195e-09 0 9.1400000016422789e-09 0 1.7300000003730998e-08 0 3.3620000007908435e-08 0 6.626000001626331e-08 0 1.1626000001618321e-07 0 1.6626000001610311e-07 0 2.1626000001602301e-07 0 2.6626000001594291e-07 0 3.1626000001586281e-07 0 3.6626000001578271e-07 0 4.1626000001570261e-07 0 4.5813000000777607e-07 0 4.9999999999984952e-07 0 5.0009999999988362e-07 0 5.0029999999995182e-07 0 5.0064999999985434e-07 0 5.0099999999975685e-07 0 5.0106999999969398e-07 0 5.0120999999956825e-07 0 5.0129999999985915e-07 0 5.0148000000044095e-07 0 5.0184000000160454e-07 0 5.0256000000393174e-07 0 5.0400000000858612e-07 0 5.0688000001789489e-07 0 5.1264000003651243e-07 0 5.2416000007374751e-07 0 5.4720000014821767e-07 0 5.9328000029715798e-07 0 6.4328000029707788e-07 0 6.9328000029699778e-07 0 7.4328000029691768e-07 0 7.9328000029683758e-07 0 8.4328000029675748e-07 0 8.9328000029667738e-07 0 9.4328000029659728e-07 0 9.7164000014814816e-07 0 9.9999999999991589e-07 0 1.00009999999995e-06 0 1.0003000000000182e-06 0 1.0006499999999207e-06 0 1.0009999999998232e-06 0 1.0010699999997603e-06 0 1.0012099999996346e-06 0 1.0014899999996e-06 0 1.0019999999997305e-06 0 1.0030199999999916e-06 0 1.0050600000005138e-06 0 1.0091400000015582e-06 0 1.0173000000036469e-06 0 1.0336200000078243e-06 0 1.0662600000161792e-06 0 1.1162600000160991e-06 0 1.166260000016019e-06 0 1.2162600000159389e-06 0 1.2662600000158588e-06 0 1.3162600000157787e-06 0 1.3662600000156986e-06 0 1.4162600000156185e-06 0 1.458130000007692e-06 0 1.4999999999997654e-06 0 1.5049999999997357e-06 0 1.505999999999643e-06 0 1.5079999999994577e-06 0 1.511999999999087e-06 0 1.5199999999983456e-06 0 1.5359999999968628e-06 0 1.5679999999938972e-06 0 1.6179999999938171e-06 0 1.667999999993737e-06 0 1.7179999999936569e-06 0 1.7679999999935768e-06 0 1.8179999999934967e-06 0 1.8679999999934166e-06 0 1.9179999999933365e-06 0 1.9589999999966926e-06 0 2.0000000000000486e-06 0 2.0001000000000827e-06 0 2.0003000000001509e-06 0 2.0006500000000534e-06 0 2.0009999999999559e-06 0 2.0010699999998931e-06 0 2.0012099999997673e-06 0 2.0014899999997327e-06 0 2.0019999999998633e-06 0 2.0030200000001244e-06 0 2.0050600000006465e-06 0 2.0091400000016909e-06 0 2.0173000000037796e-06 0 2.033620000007957e-06 0 2.0662600000163119e-06 0 2.1162600000162318e-06 0 2.1662600000161517e-06 0 2.2162600000160716e-06 0 2.2662600000159915e-06 0 2.3162600000159114e-06 0 2.3662600000158313e-06 0 2.4162600000157512e-06 0 2.4581300000078247e-06 0 2.4999999999998981e-06 0 2.5000999999999322e-06 0 2.5003000000000004e-06 0 2.500649999999903e-06 0 2.5009999999998055e-06 0 2.5010699999997426e-06 0 2.5012099999996169e-06 0 2.5012999999999078e-06 0 2.5014800000004896e-06 0 2.5018400000016532e-06 0 2.5025600000039804e-06 0 2.5040000000086347e-06 0 2.5068800000179435e-06 0 2.5112999999998484e-06 0 2.5118760000016668e-06 0 2.5130280000053035e-06 0 2.5153320000127939e-06 0 2.5199400000277747e-06 0 2.5291560000575194e-06 0 2.5475880001170088e-06 0 2.5844520002362044e-06 0 2.6344520002361243e-06 0 2.6844520002360442e-06 0 2.7344520002359641e-06 0 2.784452000235884e-06 0 2.8344520002358039e-06 0 2.8844520002357238e-06 0 2.9344520002356437e-06 0 2.9672260001179125e-06 0 2.9999999999999645e-06 0 3.0000999999999986e-06 0 3.0003000000000668e-06 0 3.0006499999999693e-06 0 3.0009999999998718e-06 0 3.001069999999809e-06 0 3.0012099999996832e-06 0 3.0014899999996486e-06 0 3.0019999999997792e-06 0 3.0030200000000402e-06 0 3.0050600000005624e-06 0 3.0091400000016068e-06 0 3.0119999999997198e-06 0 3.0120073520312467e-06 0.036760157634888047 3.0120220560943007e-06 0.11028047290466414 3.0120514642204086e-06 0.25732110344421633 3.0121102804726244e-06 0.5514023645233207 3.0122279129770561e-06 1.1395648866815296 3.0124631779861362e-06 2.3158899320821491 3.0129337080042964e-06 4.6685400228833887 3.0132348686766515e-06 5 3.0135914349197629e-06 5 3.0139627095852883e-06 5 3.0147052589163392e-06 5 3.016190357578441e-06 5 3.0183097521391169e-06 5 3.0184068898265505e-06 5 3.0186011652014177e-06 5 3.0189897159513691e-06 5 3.0193097521390242e-06 5 3.0194840032100618e-06 5 3.0198325053523538e-06 5 3.0205295096369378e-06 5 3.0219235182061058e-06 5 3.0241116967082149e-06 5 3.0242086352097117e-06 5 3.0244025122124884e-06 5 3.0247902662180418e-06 5 3.0251116967081222e-06 5 3.0252852672042058e-06 5 3.0256324081963729e-06 5 3.0263266901804902e-06 5 3.0277152541489417e-06 5 3.029907747478626e-06 5 3.0323934483297236e-06 5 3.0346461047591703e-06 5 3.0368579413645336e-06 5 3.0390221428943254e-06 5 3.0412547698324688e-06 5 3.0434585961314382e-06 5 3.0456899269559745e-06 5 3.0478921795146739e-06 5 3.0501161559816359e-06 5 3.0502129813563938e-06 5 3.0504066321059096e-06 5 3.050793933605158e-06 5 3.0511161559815432e-06 5 3.0512893425711785e-06 5 3.0516357157506658e-06 5 3.0523284621094236e-06 5 3.0537139548269393e-06 5 3.0559088928521112e-06 5 3.0583929601468544e-06 5 3.0606472216664939e-06 5 3.0611161559814838e-06 5 3.0613372026418433e-06 5 3.0613920063930072e-06 5 3.0614879129573815e-06 5 3.0615144585243413e-06 5 3.0615609132665211e-06 5 3.0615737712754495e-06 5 3.0615962727915079e-06 5 3.0616045544249165e-06 5 3.0616098677673474e-06 5 3.0616129118197707e-06 5 3.061614691158383e-06 5 3.061615727424508e-06 5 3.0616164009239586e-06 5 3.0616170327904795e-06 5 3.0616175295513151e-06 5 3.0616181141201668e-06 5 3.0616192832576532e-06 5 3.061621621532843e-06 5 3.0616262980832226e-06 5 3.0616356511839818e-06 5 3.0616543573855001e-06 5 3.0616917697885368e-06 5 3.0617665945946101e-06 5 3.0619162442067568e-06 5 3.0622155434308334e-06 5 3.0628141418792033e-06 5 3.0640113387759432e-06 5 3.0664057325692062e-06 5 3.0691268298945352e-06 5 3.0722518989335836e-06 5 3.0755930962055641e-06 5 3.0797431498758542e-06 5 3.0846132153682267e-06 5 3.0909839668516546e-06 5 3.0990912256400032e-06 5 3.1109055103721583e-06 5 3.1199775501265618e-06 5 3.1209775501264692e-06 5 3.1219510434603737e-06 5 3.123898030127966e-06 5 3.1277920034631507e-06 5 3.128792003463058e-06 5 3.1298847767947339e-06 5 3.1309775501264098e-06 5 3.1311961047927449e-06 5 3.1316332141254153e-06 5 3.132507432790756e-06 5 3.1342558701214374e-06 5 3.1377527447828003e-06 5 3.1447464941055259e-06 5 3.1570238457376103e-06 5 3.169967668616375e-06 5 3.1792744972648345e-06 5 3.1880261083733815e-06 5 3.1968863574336447e-06 5 3.2083031602789854e-06 5 3.2220961031015957e-06 5 3.2314900035761498e-06 5 3.2404165366069129e-06 5 3.2494156640850563e-06 5 3.2612424525238319e-06 5 3.2737456763902439e-06 5 3.2846521856703687e-06 5 3.2945975668686404e-06 5 3.3046574861731251e-06 5 3.3152066651748191e-06 5 3.3303558952639534e-06 5 3.3437543430208262e-06 5 3.3539459505889033e-06 5 3.3641136639650168e-06 5 3.3743154896168515e-06 5 3.3869655327685086e-06 5 3.4044499062661424e-06 5 3.4211022211468912e-06 5 3.4355727319176476e-06 5 3.4485631791891271e-06 5 3.4610935139738671e-06 5 3.4735426313870204e-06 5 3.4867713156934172e-06 5 3.4933856578466156e-06 5 3.499999999999814e-06 5 3.5005983760835226e-06 5 3.5009999999999382e-06 5 3.5011196752167233e-06 5 3.5013590256500766e-06 5 3.5015983760834299e-06 5 3.5020770769501365e-06 5 3.5030344786835498e-06 5 3.5049492821503762e-06 5 3.5087788890840292e-06 5 3.5164381029513352e-06 5 3.5263212535476419e-06 5 3.5366371995170561e-06 5 3.5470283681060533e-06 5 3.5591078799636269e-06 5 3.5749257219813875e-06 5 3.5938740270806142e-06 5 3.6103909770127292e-06 5 3.624105672399465e-06 5 3.6362934308278166e-06 5 3.6490725321414175e-06 5 3.6605790223616895e-06 5 3.6731371480557603e-06 5 3.6907685852015457e-06 5 3.7137126618050267e-06 5 3.7344122790518557e-06 5 3.7514968602573358e-06 5 3.7659442756333549e-06 5 3.7783546281034298e-06 5 3.789912918107782e-06 5 3.8015502303375293e-06 5 3.8138771296047057e-06 5 3.8323647086728214e-06 5 3.8568359771468802e-06 5 3.8780099450427472e-06 5 3.8938022094603571e-06 5 3.9079113781151625e-06 5 3.9210317374111393e-06 5 3.9329965694668168e-06 5 3.9453808124334435e-06 5 3.9579144787134195e-06 5 3.9752330372180237e-06 5 3.9876165186091689e-06 5 4.0000000000000972e-06 5 4.0001000000001313e-06 5 4.0003000000001995e-06 5 4.000650000000102e-06 5 4.0010000000000046e-06 5 4.0010699999999417e-06 5 4.001209999999816e-06 5 4.0014899999997813e-06 5 4.0019999999999119e-06 5 4.003020000000173e-06 5 4.0050600000006951e-06 5 4.0091400000017395e-06 5 4.0173000000038282e-06 5 4.0336200000080057e-06 5 4.0507049849855536e-06 5 4.0647118061357557e-06 5 4.0763612613181621e-06 5 4.0896232236938782e-06 5 4.1017938909330889e-06 5 4.1190755976415559e-06 5 4.1407302293627879e-06 5 4.1605746585030891e-06 5 4.1757842378362716e-06 5 4.1903295049127744e-06 5 4.204670839506831e-06 5 4.2173807455819171e-06 5 4.2294815602575073e-06 5 4.2416462079023897e-06 5 4.2552178917151882e-06 5 4.2752898590740079e-06 5 4.3030154700434212e-06 5 4.318928752971565e-06 5 4.333067271853697e-06 5 4.347144700132333e-06 5 4.3600587337369687e-06 5 4.3720864240130112e-06 5 4.3842143046164423e-06 5 4.3969058225799655e-06 5 4.4161107103017454e-06 5 4.4407523527596054e-06 5 4.4652059782988082e-06 5 4.4826029891493775e-06 5 4.4999999999999468e-06 5 4.5000999999999809e-06 5 4.5003000000000491e-06 5 4.5006499999999516e-06 5 4.5009999999998541e-06 5 4.5010699999997912e-06 5 4.5012099999996655e-06 5 4.5012999999999564e-06 5 4.5014800000005382e-06 5 4.5018400000017018e-06 5 4.502560000004029e-06 5 4.5040000000086833e-06 5 4.5068800000179921e-06 5 4.511299999999897e-06 5 4.5118760000017154e-06 2.1199999909080707 4.5130280000053521e-06 0 4.5153320000128425e-06 0 4.5199400000278233e-06 0 4.529156000057568e-06 0 4.5426197400812596e-06 0 4.5603257558576426e-06 0 4.5845911891668166e-06 0)
V_bus_low_17 bus_low_17 0 PWL(0 0 1.0000000003410059e-10 0 3.0000000010230177e-10 0 6.5000000000481339e-10 0 9.9999999990732502e-10 0 1.0699999998444593e-09 0 1.2099999997187277e-09 0 1.4899999996841051e-09 0 1.99999999981465e-09 0 3.0200000000757399e-09 0 5.0600000005979195e-09 0 9.1400000016422789e-09 0 1.7300000003730998e-08 0 3.3620000007908435e-08 0 6.626000001626331e-08 0 1.1626000001618321e-07 0 1.6626000001610311e-07 0 2.1626000001602301e-07 0 2.6626000001594291e-07 0 3.1626000001586281e-07 0 3.6626000001578271e-07 0 4.1626000001570261e-07 0 4.5813000000777607e-07 0 4.9999999999984952e-07 0 5.0009999999988362e-07 0 5.0029999999995182e-07 0 5.0064999999985434e-07 0 5.0099999999975685e-07 0 5.0106999999969398e-07 0 5.0120999999956825e-07 0 5.0129999999985915e-07 0 5.0148000000044095e-07 0 5.0184000000160454e-07 0 5.0256000000393174e-07 0 5.0400000000858612e-07 0 5.0688000001789489e-07 0 5.1264000003651243e-07 0 5.2416000007374751e-07 0 5.4720000014821767e-07 0 5.9328000029715798e-07 0 6.4328000029707788e-07 0 6.9328000029699778e-07 0 7.4328000029691768e-07 0 7.9328000029683758e-07 0 8.4328000029675748e-07 0 8.9328000029667738e-07 0 9.4328000029659728e-07 0 9.7164000014814816e-07 0 9.9999999999991589e-07 0 1.00009999999995e-06 0 1.0003000000000182e-06 0 1.0006499999999207e-06 0 1.0009999999998232e-06 0 1.0010699999997603e-06 0 1.0012099999996346e-06 0 1.0014899999996e-06 0 1.0019999999997305e-06 0 1.0030199999999916e-06 0 1.0050600000005138e-06 0 1.0091400000015582e-06 0 1.0173000000036469e-06 0 1.0336200000078243e-06 0 1.0662600000161792e-06 0 1.1162600000160991e-06 0 1.166260000016019e-06 0 1.2162600000159389e-06 0 1.2662600000158588e-06 0 1.3162600000157787e-06 0 1.3662600000156986e-06 0 1.4162600000156185e-06 0 1.458130000007692e-06 0 1.4999999999997654e-06 0 1.5049999999997357e-06 0 1.505999999999643e-06 0 1.5079999999994577e-06 0 1.511999999999087e-06 0 1.5199999999983456e-06 0 1.5359999999968628e-06 0 1.5679999999938972e-06 0 1.6179999999938171e-06 0 1.667999999993737e-06 0 1.7179999999936569e-06 0 1.7679999999935768e-06 0 1.8179999999934967e-06 0 1.8679999999934166e-06 0 1.9179999999933365e-06 0 1.9589999999966926e-06 0 2.0000000000000486e-06 0 2.0001000000000827e-06 0 2.0003000000001509e-06 0 2.0006500000000534e-06 0 2.0009999999999559e-06 0 2.0010699999998931e-06 0 2.0012099999997673e-06 0 2.0014899999997327e-06 0 2.0019999999998633e-06 0 2.0030200000001244e-06 0 2.0050600000006465e-06 0 2.0091400000016909e-06 0 2.0173000000037796e-06 0 2.033620000007957e-06 0 2.0662600000163119e-06 0 2.1162600000162318e-06 0 2.1662600000161517e-06 0 2.2162600000160716e-06 0 2.2662600000159915e-06 0 2.3162600000159114e-06 0 2.3662600000158313e-06 0 2.4162600000157512e-06 0 2.4581300000078247e-06 0 2.4999999999998981e-06 0 2.5000999999999322e-06 0 2.5003000000000004e-06 0 2.500649999999903e-06 0 2.5009999999998055e-06 0 2.5010699999997426e-06 0 2.5012099999996169e-06 0 2.5012999999999078e-06 0 2.5014800000004896e-06 0 2.5018400000016532e-06 0 2.5025600000039804e-06 0 2.5040000000086347e-06 0 2.5068800000179435e-06 0 2.5112999999998484e-06 0 2.5118760000016668e-06 0 2.5130280000053035e-06 0 2.5153320000127939e-06 0 2.5199400000277747e-06 0 2.5291560000575194e-06 0 2.5475880001170088e-06 0 2.5844520002362044e-06 0 2.6344520002361243e-06 0 2.6844520002360442e-06 0 2.7344520002359641e-06 0 2.784452000235884e-06 0 2.8344520002358039e-06 0 2.8844520002357238e-06 0 2.9344520002356437e-06 0 2.9672260001179125e-06 0 2.9999999999999645e-06 0 3.0000999999999986e-06 0 3.0003000000000668e-06 0 3.0006499999999693e-06 0 3.0009999999998718e-06 0 3.001069999999809e-06 0 3.0012099999996832e-06 0 3.0014899999996486e-06 0 3.0019999999997792e-06 0 3.0030200000000402e-06 0 3.0050600000005624e-06 0 3.0091400000016068e-06 0 3.0119999999997198e-06 0 3.0120073520312467e-06 0 3.0120220560943007e-06 0 3.0120514642204086e-06 0 3.0121102804726244e-06 0 3.0122279129770561e-06 0 3.0124631779861362e-06 0 3.0129337080042964e-06 0 3.0132348686766515e-06 0 3.0135914349197629e-06 0 3.0139627095852883e-06 0 3.0147052589163392e-06 0 3.016190357578441e-06 0 3.0183097521391169e-06 0 3.0184068898265505e-06 0 3.0186011652014177e-06 0 3.0189897159513691e-06 0 3.0193097521390242e-06 0 3.0194840032100618e-06 0 3.0198325053523538e-06 0 3.0205295096369378e-06 0 3.0219235182061058e-06 0 3.0241116967082149e-06 0 3.0242086352097117e-06 0 3.0244025122124884e-06 0 3.0247902662180418e-06 0 3.0251116967081222e-06 0 3.0252852672042058e-06 0 3.0256324081963729e-06 0 3.0263266901804902e-06 0 3.0277152541489417e-06 0 3.029907747478626e-06 0 3.0323934483297236e-06 0 3.0346461047591703e-06 0 3.0368579413645336e-06 0 3.0390221428943254e-06 0 3.0412547698324688e-06 0 3.0434585961314382e-06 0 3.0456899269559745e-06 0 3.0478921795146739e-06 0 3.0501161559816359e-06 0 3.0502129813563938e-06 0 3.0504066321059096e-06 0 3.050793933605158e-06 0 3.0511161559815432e-06 0 3.0512893425711785e-06 0 3.0516357157506658e-06 0 3.0523284621094236e-06 0 3.0537139548269393e-06 0 3.0559088928521112e-06 0 3.0583929601468544e-06 0 3.0606472216664939e-06 0 3.0611161559814838e-06 0 3.0613372026418433e-06 0 3.0613920063930072e-06 0 3.0614879129573815e-06 0 3.0615144585243413e-06 0 3.0615609132665211e-06 0 3.0615737712754495e-06 0 3.0615962727915079e-06 0 3.0616045544249165e-06 0 3.0616098677673474e-06 0 3.0616129118197707e-06 0 3.061614691158383e-06 0 3.061615727424508e-06 0 3.0616164009239586e-06 0 3.0616170327904795e-06 0 3.0616175295513151e-06 0 3.0616181141201668e-06 0 3.0616192832576532e-06 0 3.061621621532843e-06 0 3.0616262980832226e-06 0 3.0616356511839818e-06 0 3.0616543573855001e-06 0 3.0616917697885368e-06 0 3.0617665945946101e-06 0 3.0619162442067568e-06 0 3.0622155434308334e-06 0 3.0628141418792033e-06 0 3.0640113387759432e-06 0 3.0664057325692062e-06 0 3.0691268298945352e-06 0 3.0722518989335836e-06 0 3.0755930962055641e-06 0 3.0797431498758542e-06 0 3.0846132153682267e-06 0 3.0909839668516546e-06 0 3.0990912256400032e-06 0 3.1109055103721583e-06 0 3.1199775501265618e-06 0 3.1209775501264692e-06 0 3.1219510434603737e-06 0 3.123898030127966e-06 0 3.1277920034631507e-06 0 3.128792003463058e-06 0 3.1298847767947339e-06 0 3.1309775501264098e-06 0 3.1311961047927449e-06 0 3.1316332141254153e-06 0 3.132507432790756e-06 0 3.1342558701214374e-06 0 3.1377527447828003e-06 0 3.1447464941055259e-06 0 3.1570238457376103e-06 0 3.169967668616375e-06 0 3.1792744972648345e-06 0 3.1880261083733815e-06 0 3.1968863574336447e-06 0 3.2083031602789854e-06 0 3.2220961031015957e-06 0 3.2314900035761498e-06 0 3.2404165366069129e-06 0 3.2494156640850563e-06 0 3.2612424525238319e-06 0 3.2737456763902439e-06 0 3.2846521856703687e-06 0 3.2945975668686404e-06 0 3.3046574861731251e-06 0 3.3152066651748191e-06 0 3.3303558952639534e-06 0 3.3437543430208262e-06 0 3.3539459505889033e-06 0 3.3641136639650168e-06 0 3.3743154896168515e-06 0 3.3869655327685086e-06 0 3.4044499062661424e-06 0 3.4211022211468912e-06 0 3.4355727319176476e-06 0 3.4485631791891271e-06 0 3.4610935139738671e-06 0 3.4735426313870204e-06 0 3.4867713156934172e-06 0 3.4933856578466156e-06 0 3.499999999999814e-06 0 3.5005983760835226e-06 0 3.5009999999999382e-06 0 3.5011196752167233e-06 0 3.5013590256500766e-06 0 3.5015983760834299e-06 0 3.5020770769501365e-06 0 3.5030344786835498e-06 0 3.5049492821503762e-06 0 3.5087788890840292e-06 0 3.5164381029513352e-06 0 3.5263212535476419e-06 0 3.5366371995170561e-06 0 3.5470283681060533e-06 0 3.5591078799636269e-06 0 3.5749257219813875e-06 0 3.5938740270806142e-06 0 3.6103909770127292e-06 0 3.624105672399465e-06 0 3.6362934308278166e-06 0 3.6490725321414175e-06 0 3.6605790223616895e-06 0 3.6731371480557603e-06 0 3.6907685852015457e-06 0 3.7137126618050267e-06 0 3.7344122790518557e-06 0 3.7514968602573358e-06 0 3.7659442756333549e-06 0 3.7783546281034298e-06 0 3.789912918107782e-06 0 3.8015502303375293e-06 0 3.8138771296047057e-06 0 3.8323647086728214e-06 0 3.8568359771468802e-06 0 3.8780099450427472e-06 0 3.8938022094603571e-06 0 3.9079113781151625e-06 0 3.9210317374111393e-06 0 3.9329965694668168e-06 0 3.9453808124334435e-06 0 3.9579144787134195e-06 0 3.9752330372180237e-06 0 3.9876165186091689e-06 0 4.0000000000000972e-06 0 4.0001000000001313e-06 0 4.0003000000001995e-06 0 4.000650000000102e-06 0 4.0010000000000046e-06 0 4.0010699999999417e-06 0 4.001209999999816e-06 0 4.0014899999997813e-06 0 4.0019999999999119e-06 0 4.003020000000173e-06 0 4.0050600000006951e-06 0 4.0091400000017395e-06 0 4.0173000000038282e-06 0 4.0336200000080057e-06 0 4.0507049849855536e-06 0 4.0647118061357557e-06 0 4.0763612613181621e-06 0 4.0896232236938782e-06 0 4.1017938909330889e-06 0 4.1190755976415559e-06 0 4.1407302293627879e-06 0 4.1605746585030891e-06 0 4.1757842378362716e-06 0 4.1903295049127744e-06 0 4.204670839506831e-06 0 4.2173807455819171e-06 0 4.2294815602575073e-06 0 4.2416462079023897e-06 0 4.2552178917151882e-06 0 4.2752898590740079e-06 0 4.3030154700434212e-06 0 4.318928752971565e-06 0 4.333067271853697e-06 0 4.347144700132333e-06 0 4.3600587337369687e-06 0 4.3720864240130112e-06 0 4.3842143046164423e-06 0 4.3969058225799655e-06 0 4.4161107103017454e-06 0 4.4407523527596054e-06 0 4.4652059782988082e-06 0 4.4826029891493775e-06 0 4.4999999999999468e-06 0 4.5000999999999809e-06 0 4.5003000000000491e-06 0 4.5006499999999516e-06 0 4.5009999999998541e-06 0 4.5010699999997912e-06 0 4.5012099999996655e-06 0 4.5012999999999564e-06 0 4.5014800000005382e-06 0 4.5018400000017018e-06 0 4.502560000004029e-06 0 4.5040000000086833e-06 0 4.5068800000179921e-06 0 4.511299999999897e-06 0 4.5118760000017154e-06 0 4.5130280000053521e-06 0 4.5153320000128425e-06 0 4.5199400000278233e-06 0 4.529156000057568e-06 0 4.5426197400812596e-06 0 4.5603257558576426e-06 0 4.5845911891668166e-06 0)
V_bus_high_17 bus_high_17 0 PWL(0 0 1.0000000003410059e-10 0 3.0000000010230177e-10 0 6.5000000000481339e-10 0 9.9999999990732502e-10 0 1.0699999998444593e-09 0 1.2099999997187277e-09 0 1.4899999996841051e-09 0 1.99999999981465e-09 0 3.0200000000757399e-09 0 5.0600000005979195e-09 0 9.1400000016422789e-09 0 1.7300000003730998e-08 0 3.3620000007908435e-08 0 6.626000001626331e-08 0 1.1626000001618321e-07 0 1.6626000001610311e-07 0 2.1626000001602301e-07 0 2.6626000001594291e-07 0 3.1626000001586281e-07 0 3.6626000001578271e-07 0 4.1626000001570261e-07 0 4.5813000000777607e-07 0 4.9999999999984952e-07 0 5.0009999999988362e-07 0 5.0029999999995182e-07 0 5.0064999999985434e-07 0 5.0099999999975685e-07 0 5.0106999999969398e-07 0 5.0120999999956825e-07 0 5.0129999999985915e-07 0 5.0148000000044095e-07 0 5.0184000000160454e-07 0 5.0256000000393174e-07 0 5.0400000000858612e-07 0 5.0688000001789489e-07 0 5.1264000003651243e-07 0 5.2416000007374751e-07 0 5.4720000014821767e-07 0 5.9328000029715798e-07 0 6.4328000029707788e-07 0 6.9328000029699778e-07 0 7.4328000029691768e-07 0 7.9328000029683758e-07 0 8.4328000029675748e-07 0 8.9328000029667738e-07 0 9.4328000029659728e-07 0 9.7164000014814816e-07 0 9.9999999999991589e-07 0 1.00009999999995e-06 0 1.0003000000000182e-06 0 1.0006499999999207e-06 0 1.0009999999998232e-06 0 1.0010699999997603e-06 0 1.0012099999996346e-06 0 1.0014899999996e-06 0 1.0019999999997305e-06 0 1.0030199999999916e-06 0 1.0050600000005138e-06 0 1.0091400000015582e-06 0 1.0173000000036469e-06 0 1.0336200000078243e-06 0 1.0662600000161792e-06 0 1.1162600000160991e-06 0 1.166260000016019e-06 0 1.2162600000159389e-06 0 1.2662600000158588e-06 0 1.3162600000157787e-06 0 1.3662600000156986e-06 0 1.4162600000156185e-06 0 1.458130000007692e-06 0 1.4999999999997654e-06 0 1.5049999999997357e-06 0 1.505999999999643e-06 0 1.5079999999994577e-06 0 1.511999999999087e-06 0 1.5199999999983456e-06 0 1.5359999999968628e-06 0 1.5679999999938972e-06 0 1.6179999999938171e-06 0 1.667999999993737e-06 0 1.7179999999936569e-06 0 1.7679999999935768e-06 0 1.8179999999934967e-06 0 1.8679999999934166e-06 0 1.9179999999933365e-06 0 1.9589999999966926e-06 0 2.0000000000000486e-06 0 2.0001000000000827e-06 0 2.0003000000001509e-06 0 2.0006500000000534e-06 0 2.0009999999999559e-06 0 2.0010699999998931e-06 0 2.0012099999997673e-06 0 2.0014899999997327e-06 0 2.0019999999998633e-06 0 2.0030200000001244e-06 0 2.0050600000006465e-06 0 2.0091400000016909e-06 0 2.0173000000037796e-06 0 2.033620000007957e-06 0 2.0662600000163119e-06 0 2.1162600000162318e-06 0 2.1662600000161517e-06 0 2.2162600000160716e-06 0 2.2662600000159915e-06 0 2.3162600000159114e-06 0 2.3662600000158313e-06 0 2.4162600000157512e-06 0 2.4581300000078247e-06 0 2.4999999999998981e-06 0 2.5000999999999322e-06 0 2.5003000000000004e-06 0 2.500649999999903e-06 0 2.5009999999998055e-06 0 2.5010699999997426e-06 0 2.5012099999996169e-06 0 2.5012999999999078e-06 0 2.5014800000004896e-06 0 2.5018400000016532e-06 0 2.5025600000039804e-06 0 2.5040000000086347e-06 0 2.5068800000179435e-06 0 2.5112999999998484e-06 0 2.5118760000016668e-06 0 2.5130280000053035e-06 0 2.5153320000127939e-06 0 2.5199400000277747e-06 0 2.5291560000575194e-06 0 2.5475880001170088e-06 0 2.5844520002362044e-06 0 2.6344520002361243e-06 0 2.6844520002360442e-06 0 2.7344520002359641e-06 0 2.784452000235884e-06 0 2.8344520002358039e-06 0 2.8844520002357238e-06 0 2.9344520002356437e-06 0 2.9672260001179125e-06 0 2.9999999999999645e-06 0 3.0000999999999986e-06 0 3.0003000000000668e-06 0 3.0006499999999693e-06 0 3.0009999999998718e-06 0 3.001069999999809e-06 0 3.0012099999996832e-06 0 3.0014899999996486e-06 0 3.0019999999997792e-06 0 3.0030200000000402e-06 0 3.0050600000005624e-06 0 3.0091400000016068e-06 0 3.0119999999997198e-06 0 3.0120073520312467e-06 0 3.0120220560943007e-06 0 3.0120514642204086e-06 0 3.0121102804726244e-06 0 3.0122279129770561e-06 0 3.0124631779861362e-06 0 3.0129337080042964e-06 0 3.0132348686766515e-06 0 3.0135914349197629e-06 0 3.0139627095852883e-06 0 3.0147052589163392e-06 0 3.016190357578441e-06 0 3.0183097521391169e-06 0 3.0184068898265505e-06 0 3.0186011652014177e-06 0 3.0189897159513691e-06 0 3.0193097521390242e-06 0 3.0194840032100618e-06 0 3.0198325053523538e-06 0 3.0205295096369378e-06 0 3.0219235182061058e-06 0 3.0241116967082149e-06 0 3.0242086352097117e-06 0 3.0244025122124884e-06 0 3.0247902662180418e-06 0 3.0251116967081222e-06 0 3.0252852672042058e-06 0 3.0256324081963729e-06 0 3.0263266901804902e-06 0 3.0277152541489417e-06 0 3.029907747478626e-06 0 3.0323934483297236e-06 0 3.0346461047591703e-06 0 3.0368579413645336e-06 0 3.0390221428943254e-06 0 3.0412547698324688e-06 0 3.0434585961314382e-06 0 3.0456899269559745e-06 0 3.0478921795146739e-06 0 3.0501161559816359e-06 0 3.0502129813563938e-06 0 3.0504066321059096e-06 0 3.050793933605158e-06 0 3.0511161559815432e-06 0 3.0512893425711785e-06 0 3.0516357157506658e-06 0 3.0523284621094236e-06 0 3.0537139548269393e-06 0 3.0559088928521112e-06 0 3.0583929601468544e-06 0 3.0606472216664939e-06 0 3.0611161559814838e-06 0 3.0613372026418433e-06 0 3.0613920063930072e-06 0 3.0614879129573815e-06 0 3.0615144585243413e-06 0 3.0615609132665211e-06 0 3.0615737712754495e-06 0 3.0615962727915079e-06 0 3.0616045544249165e-06 0 3.0616098677673474e-06 0 3.0616129118197707e-06 0 3.061614691158383e-06 0 3.061615727424508e-06 0 3.0616164009239586e-06 0 3.0616170327904795e-06 0 3.0616175295513151e-06 0 3.0616181141201668e-06 0 3.0616192832576532e-06 0 3.061621621532843e-06 0 3.0616262980832226e-06 0 3.0616356511839818e-06 0 3.0616543573855001e-06 0 3.0616917697885368e-06 0 3.0617665945946101e-06 0 3.0619162442067568e-06 0 3.0622155434308334e-06 0 3.0628141418792033e-06 0 3.0640113387759432e-06 0 3.0664057325692062e-06 0 3.0691268298945352e-06 0 3.0722518989335836e-06 0 3.0755930962055641e-06 0 3.0797431498758542e-06 0 3.0846132153682267e-06 0 3.0909839668516546e-06 0 3.0990912256400032e-06 0 3.1109055103721583e-06 0 3.1199775501265618e-06 0 3.1209775501264692e-06 0 3.1219510434603737e-06 0 3.123898030127966e-06 0 3.1277920034631507e-06 0 3.128792003463058e-06 0 3.1298847767947339e-06 0 3.1309775501264098e-06 0 3.1311961047927449e-06 0 3.1316332141254153e-06 0 3.132507432790756e-06 0 3.1342558701214374e-06 0 3.1377527447828003e-06 0 3.1447464941055259e-06 0 3.1570238457376103e-06 0 3.169967668616375e-06 0 3.1792744972648345e-06 0 3.1880261083733815e-06 0 3.1968863574336447e-06 0 3.2083031602789854e-06 0 3.2220961031015957e-06 0 3.2314900035761498e-06 0 3.2404165366069129e-06 0 3.2494156640850563e-06 0 3.2612424525238319e-06 0 3.2737456763902439e-06 0 3.2846521856703687e-06 0 3.2945975668686404e-06 0 3.3046574861731251e-06 0 3.3152066651748191e-06 0 3.3303558952639534e-06 0 3.3437543430208262e-06 0 3.3539459505889033e-06 0 3.3641136639650168e-06 0 3.3743154896168515e-06 0 3.3869655327685086e-06 0 3.4044499062661424e-06 0 3.4211022211468912e-06 0 3.4355727319176476e-06 0 3.4485631791891271e-06 0 3.4610935139738671e-06 0 3.4735426313870204e-06 0 3.4867713156934172e-06 0 3.4933856578466156e-06 0 3.499999999999814e-06 0 3.5005983760835226e-06 0 3.5009999999999382e-06 0 3.5011196752167233e-06 0 3.5013590256500766e-06 0 3.5015983760834299e-06 0 3.5020770769501365e-06 0 3.5030344786835498e-06 0 3.5049492821503762e-06 0 3.5087788890840292e-06 0 3.5164381029513352e-06 0 3.5263212535476419e-06 0 3.5366371995170561e-06 0 3.5470283681060533e-06 0 3.5591078799636269e-06 0 3.5749257219813875e-06 0 3.5938740270806142e-06 0 3.6103909770127292e-06 0 3.624105672399465e-06 0 3.6362934308278166e-06 0 3.6490725321414175e-06 0 3.6605790223616895e-06 0 3.6731371480557603e-06 0 3.6907685852015457e-06 0 3.7137126618050267e-06 0 3.7344122790518557e-06 0 3.7514968602573358e-06 0 3.7659442756333549e-06 0 3.7783546281034298e-06 0 3.789912918107782e-06 0 3.8015502303375293e-06 0 3.8138771296047057e-06 0 3.8323647086728214e-06 0 3.8568359771468802e-06 0 3.8780099450427472e-06 0 3.8938022094603571e-06 0 3.9079113781151625e-06 0 3.9210317374111393e-06 0 3.9329965694668168e-06 0 3.9453808124334435e-06 0 3.9579144787134195e-06 0 3.9752330372180237e-06 0 3.9876165186091689e-06 0 4.0000000000000972e-06 0 4.0001000000001313e-06 0 4.0003000000001995e-06 0 4.000650000000102e-06 0 4.0010000000000046e-06 0 4.0010699999999417e-06 0 4.001209999999816e-06 0 4.0014899999997813e-06 0 4.0019999999999119e-06 0 4.003020000000173e-06 0 4.0050600000006951e-06 0 4.0091400000017395e-06 0 4.0173000000038282e-06 0 4.0336200000080057e-06 0 4.0507049849855536e-06 0 4.0647118061357557e-06 0 4.0763612613181621e-06 0 4.0896232236938782e-06 0 4.1017938909330889e-06 0 4.1190755976415559e-06 0 4.1407302293627879e-06 0 4.1605746585030891e-06 0 4.1757842378362716e-06 0 4.1903295049127744e-06 0 4.204670839506831e-06 0 4.2173807455819171e-06 0 4.2294815602575073e-06 0 4.2416462079023897e-06 0 4.2552178917151882e-06 0 4.2752898590740079e-06 0 4.3030154700434212e-06 0 4.318928752971565e-06 0 4.333067271853697e-06 0 4.347144700132333e-06 0 4.3600587337369687e-06 0 4.3720864240130112e-06 0 4.3842143046164423e-06 0 4.3969058225799655e-06 0 4.4161107103017454e-06 0 4.4407523527596054e-06 0 4.4652059782988082e-06 0 4.4826029891493775e-06 0 4.4999999999999468e-06 0 4.5000999999999809e-06 0 4.5003000000000491e-06 0 4.5006499999999516e-06 0 4.5009999999998541e-06 0 4.5010699999997912e-06 0 4.5012099999996655e-06 0 4.5012999999999564e-06 0 4.5014800000005382e-06 0 4.5018400000017018e-06 0 4.502560000004029e-06 0 4.5040000000086833e-06 0 4.5068800000179921e-06 0 4.511299999999897e-06 0 4.5118760000017154e-06 0 4.5130280000053521e-06 0 4.5153320000128425e-06 0 4.5199400000278233e-06 0 4.529156000057568e-06 0 4.5426197400812596e-06 0 4.5603257558576426e-06 0 4.5845911891668166e-06 0)
.OPTIONS TIMEINT RELTOL=1e-09 ABSTOL=1e-13
.TRAN 2.5000000000000002e-10 4.5845911891668166e-06 0 2.5000000000000002e-10 UIC
.PRINT TRAN FORMAT=CSV PRECISION=17 V(n_D1) V(n_p5V)
.END
