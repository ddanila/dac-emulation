S600 firmware I/O service fixture
Vhost n_CABLE_5V n_CABLE_GND PWL(0 0 1u 5)
Vfixture_clock fixture_clock 0 PULSE(0 5 500n 1n 1n 499n 1u)
Vfixture_reset fixture_reset 0 PWL(0 0 1000000n 0 1000001n 5)
R1_2 0 n_SENSE7 910
R1_3 0 n_SENSE6 910
R1_4 0 n_SENSE5 910
R1_5 0 n_SENSE4 910
R1_6 0 n_SENSE3 910
R1_7 0 n_SENSE2 910
R1_8 0 n_SENSE1 910
R1_9 0 n_SENSE0 910
R2_2 n_p5V n_BASE6 4.7k
R2_3 n_p5V n_BASE0 4.7k
R2_4 n_p5V n_BASE1 4.7k
R2_5 n_p5V n_BASE4 4.7k
R2_6 n_p5V n_BASE7 4.7k
R2_7 n_p5V n_BASE5 4.7k
R2_8 n_p5V n_BASE2 4.7k
R2_9 n_p5V n_BASE3 4.7k
R9.1 n_ROW7 n_BASE7 3.9k
R9.2 n_ROW6 n_BASE6 3.9k
R9.3 n_ROW0 n_BASE0 3.9k
R9.4 n_ROW5 n_BASE5 3.9k
R9.5 n_ROW1 n_BASE1 3.9k
R9.6 n_ROW2 n_BASE2 3.9k
R9.7 n_ROW3 n_BASE3 3.9k
R9.8 n_ROW4 n_BASE4 3.9k
QV4.1 n_SENSE4 n_BASE4 n_p5V PNP_NOMINAL
QV4.2 n_SENSE6 n_BASE6 n_p5V PNP_NOMINAL
QV4.3 n_SENSE0 n_BASE0 n_p5V PNP_NOMINAL
QV4.4 n_SENSE1 n_BASE1 n_p5V PNP_NOMINAL
QV4.5 n_SENSE7 n_BASE7 n_p5V PNP_NOMINAL
QV4.6 n_SENSE5 n_BASE5 n_p5V PNP_NOMINAL
QV4.7 n_SENSE3 n_BASE3 n_p5V PNP_NOMINAL
QV4.8 n_SENSE2 n_BASE2 n_p5V PNP_NOMINAL
.model D_NOMINAL D(IS=1e-14 N=1)
.model NPN_NOMINAL NPN(IS=1e-14 BF=100 VAF=100)
.model PNP_NOMINAL PNP(IS=1e-14 BF=100 VAF=100)
.model CONTACT_NOMINAL SW(RON=100 ROFF=1t VT=2.5 VH=0)
.model SINK_NOMINAL SW(RON=20 ROFF=1t VT=2.5 VH=0)
Sdriver0 n_COL0 0 sink0 0 SINK_NOMINAL
Scontact0 n_COL0 n_ROW0 contact0 0 CONTACT_NOMINAL
Scontact1 n_COL0 n_ROW1 contact1 0 CONTACT_NOMINAL
Scontact2 n_COL0 n_ROW2 contact2 0 CONTACT_NOMINAL
Scontact3 n_COL0 n_ROW3 contact3 0 CONTACT_NOMINAL
Scontact4 n_COL0 n_ROW4 contact4 0 CONTACT_NOMINAL
Scontact5 n_COL0 n_ROW5 contact5 0 CONTACT_NOMINAL
Scontact6 n_COL0 n_ROW6 contact6 0 CONTACT_NOMINAL
Scontact7 n_COL0 n_ROW7 contact7 0 CONTACT_NOMINAL
Sdriver1 n_COL1 0 sink1 0 SINK_NOMINAL
Scontact8 n_COL1 n_ROW0 contact8 0 CONTACT_NOMINAL
Scontact9 n_COL1 n_ROW1 contact9 0 CONTACT_NOMINAL
Scontact10 n_COL1 n_ROW2 contact10 0 CONTACT_NOMINAL
Scontact11 n_COL1 n_ROW3 contact11 0 CONTACT_NOMINAL
Scontact12 n_COL1 n_ROW4 contact12 0 CONTACT_NOMINAL
Scontact13 n_COL1 n_ROW5 contact13 0 CONTACT_NOMINAL
Scontact14 n_COL1 n_ROW6 contact14 0 CONTACT_NOMINAL
Scontact15 n_COL1 n_ROW7 contact15 0 CONTACT_NOMINAL
Sdriver2 n_COL2 0 sink2 0 SINK_NOMINAL
Scontact16 n_COL2 n_ROW0 contact16 0 CONTACT_NOMINAL
Scontact17 n_COL2 n_ROW1 contact17 0 CONTACT_NOMINAL
Scontact18 n_COL2 n_ROW2 contact18 0 CONTACT_NOMINAL
Scontact19 n_COL2 n_ROW3 contact19 0 CONTACT_NOMINAL
Scontact20 n_COL2 n_ROW4 contact20 0 CONTACT_NOMINAL
Scontact21 n_COL2 n_ROW5 contact21 0 CONTACT_NOMINAL
Scontact22 n_COL2 n_ROW6 contact22 0 CONTACT_NOMINAL
Scontact23 n_COL2 n_ROW7 contact23 0 CONTACT_NOMINAL
Sdriver3 n_COL3 0 sink3 0 SINK_NOMINAL
Scontact24 n_COL3 n_ROW0 contact24 0 CONTACT_NOMINAL
Scontact25 n_COL3 n_ROW1 contact25 0 CONTACT_NOMINAL
Scontact26 n_COL3 n_ROW2 contact26 0 CONTACT_NOMINAL
Scontact27 n_COL3 n_ROW3 contact27 0 CONTACT_NOMINAL
Scontact28 n_COL3 n_ROW4 contact28 0 CONTACT_NOMINAL
Scontact29 n_COL3 n_ROW5 contact29 0 CONTACT_NOMINAL
Scontact30 n_COL3 n_ROW6 contact30 0 CONTACT_NOMINAL
Scontact31 n_COL3 n_ROW7 contact31 0 CONTACT_NOMINAL
Sdriver4 n_COL4 0 sink4 0 SINK_NOMINAL
Scontact32 n_COL4 n_ROW0 contact32 0 CONTACT_NOMINAL
Scontact33 n_COL4 n_ROW1 contact33 0 CONTACT_NOMINAL
Scontact34 n_COL4 n_ROW2 contact34 0 CONTACT_NOMINAL
Scontact35 n_COL4 n_ROW3 contact35 0 CONTACT_NOMINAL
Scontact36 n_COL4 n_ROW4 contact36 0 CONTACT_NOMINAL
Scontact37 n_COL4 n_ROW5 contact37 0 CONTACT_NOMINAL
Scontact38 n_COL4 n_ROW6 contact38 0 CONTACT_NOMINAL
Scontact39 n_COL4 n_ROW7 contact39 0 CONTACT_NOMINAL
Sdriver5 n_COL5 0 sink5 0 SINK_NOMINAL
Scontact40 n_COL5 n_ROW0 contact40 0 CONTACT_NOMINAL
Scontact41 n_COL5 n_ROW1 contact41 0 CONTACT_NOMINAL
Scontact42 n_COL5 n_ROW2 contact42 0 CONTACT_NOMINAL
Scontact43 n_COL5 n_ROW3 contact43 0 CONTACT_NOMINAL
Scontact44 n_COL5 n_ROW4 contact44 0 CONTACT_NOMINAL
Scontact45 n_COL5 n_ROW5 contact45 0 CONTACT_NOMINAL
Scontact46 n_COL5 n_ROW6 contact46 0 CONTACT_NOMINAL
Scontact47 n_COL5 n_ROW7 contact47 0 CONTACT_NOMINAL
Sdriver6 n_COL6 0 sink6 0 SINK_NOMINAL
Scontact48 n_COL6 n_ROW0 contact48 0 CONTACT_NOMINAL
Scontact49 n_COL6 n_ROW1 contact49 0 CONTACT_NOMINAL
Scontact50 n_COL6 n_ROW2 contact50 0 CONTACT_NOMINAL
Scontact51 n_COL6 n_ROW3 contact51 0 CONTACT_NOMINAL
Scontact52 n_COL6 n_ROW4 contact52 0 CONTACT_NOMINAL
Scontact53 n_COL6 n_ROW5 contact53 0 CONTACT_NOMINAL
Scontact54 n_COL6 n_ROW6 contact54 0 CONTACT_NOMINAL
Scontact55 n_COL6 n_ROW7 contact55 0 CONTACT_NOMINAL
Sdriver7 n_COL7 0 sink7 0 SINK_NOMINAL
Scontact56 n_COL7 n_ROW0 contact56 0 CONTACT_NOMINAL
Scontact57 n_COL7 n_ROW1 contact57 0 CONTACT_NOMINAL
Scontact58 n_COL7 n_ROW2 contact58 0 CONTACT_NOMINAL
Scontact59 n_COL7 n_ROW3 contact59 0 CONTACT_NOMINAL
Scontact60 n_COL7 n_ROW4 contact60 0 CONTACT_NOMINAL
Scontact61 n_COL7 n_ROW5 contact61 0 CONTACT_NOMINAL
Scontact62 n_COL7 n_ROW6 contact62 0 CONTACT_NOMINAL
Scontact63 n_COL7 n_ROW7 contact63 0 CONTACT_NOMINAL
Sdriver8 n_COL8 0 sink8 0 SINK_NOMINAL
Scontact64 n_COL8 n_ROW0 contact64 0 CONTACT_NOMINAL
Scontact65 n_COL8 n_ROW1 contact65 0 CONTACT_NOMINAL
Scontact66 n_COL8 n_ROW2 contact66 0 CONTACT_NOMINAL
Scontact67 n_COL8 n_ROW3 contact67 0 CONTACT_NOMINAL
Scontact68 n_COL8 n_ROW4 contact68 0 CONTACT_NOMINAL
Scontact69 n_COL8 n_ROW5 contact69 0 CONTACT_NOMINAL
Scontact70 n_COL8 n_ROW6 contact70 0 CONTACT_NOMINAL
Scontact71 n_COL8 n_ROW7 contact71 0 CONTACT_NOMINAL
Sdriver9 n_COL9 0 sink9 0 SINK_NOMINAL
Scontact72 n_COL9 n_ROW0 contact72 0 CONTACT_NOMINAL
Scontact73 n_COL9 n_ROW1 contact73 0 CONTACT_NOMINAL
Scontact74 n_COL9 n_ROW2 contact74 0 CONTACT_NOMINAL
Scontact75 n_COL9 n_ROW3 contact75 0 CONTACT_NOMINAL
Scontact76 n_COL9 n_ROW4 contact76 0 CONTACT_NOMINAL
Scontact77 n_COL9 n_ROW5 contact77 0 CONTACT_NOMINAL
Scontact78 n_COL9 n_ROW6 contact78 0 CONTACT_NOMINAL
Scontact79 n_COL9 n_ROW7 contact79 0 CONTACT_NOMINAL
Sdriver10 n_COL10 0 sink10 0 SINK_NOMINAL
Scontact80 n_COL10 n_ROW0 contact80 0 CONTACT_NOMINAL
Scontact81 n_COL10 n_ROW1 contact81 0 CONTACT_NOMINAL
Scontact82 n_COL10 n_ROW2 contact82 0 CONTACT_NOMINAL
Scontact83 n_COL10 n_ROW3 contact83 0 CONTACT_NOMINAL
Scontact84 n_COL10 n_ROW4 contact84 0 CONTACT_NOMINAL
Scontact85 n_COL10 n_ROW5 contact85 0 CONTACT_NOMINAL
Scontact86 n_COL10 n_ROW6 contact86 0 CONTACT_NOMINAL
Scontact87 n_COL10 n_ROW7 contact87 0 CONTACT_NOMINAL
Sdriver11 n_COL11 0 sink11 0 SINK_NOMINAL
Scontact88 n_COL11 n_ROW0 contact88 0 CONTACT_NOMINAL
Scontact89 n_COL11 n_ROW1 contact89 0 CONTACT_NOMINAL
Scontact90 n_COL11 n_ROW2 contact90 0 CONTACT_NOMINAL
Scontact91 n_COL11 n_ROW3 contact91 0 CONTACT_NOMINAL
Scontact92 n_COL11 n_ROW4 contact92 0 CONTACT_NOMINAL
Scontact93 n_COL11 n_ROW5 contact93 0 CONTACT_NOMINAL
Scontact94 n_COL11 n_ROW6 contact94 0 CONTACT_NOMINAL
Scontact95 n_COL11 n_ROW7 contact95 0 CONTACT_NOMINAL
Sdriver12 n_COL12 0 sink12 0 SINK_NOMINAL
Scontact96 n_COL12 n_ROW0 contact96 0 CONTACT_NOMINAL
Scontact97 n_COL12 n_ROW1 contact97 0 CONTACT_NOMINAL
Scontact98 n_COL12 n_ROW2 contact98 0 CONTACT_NOMINAL
Scontact99 n_COL12 n_ROW3 contact99 0 CONTACT_NOMINAL
Scontact100 n_COL12 n_ROW4 contact100 0 CONTACT_NOMINAL
Scontact101 n_COL12 n_ROW5 contact101 0 CONTACT_NOMINAL
Scontact102 n_COL12 n_ROW6 contact102 0 CONTACT_NOMINAL
Scontact103 n_COL12 n_ROW7 contact103 0 CONTACT_NOMINAL
Rlatch0 n_SENSE0 0 1g
Clatch0 n_SENSE0 0 10p
Rlatch1 n_SENSE1 0 1g
Clatch1 n_SENSE1 0 10p
Rlatch2 n_SENSE2 0 1g
Clatch2 n_SENSE2 0 10p
Rlatch3 n_SENSE3 0 1g
Clatch3 n_SENSE3 0 10p
Rlatch4 n_SENSE4 0 1g
Clatch4 n_SENSE4 0 10p
Rlatch5 n_SENSE5 0 1g
Clatch5 n_SENSE5 0 10p
Rlatch6 n_SENSE6 0 1g
Clatch6 n_SENSE6 0 10p
Rlatch7 n_SENSE7 0 1g
Clatch7 n_SENSE7 0 10p
R10.1 n_p5V n_TA_TAKT 560
R10.2 n_p5V n_TA_DATEN 560
R11.1 n_LED_SISO_N n_LED_SISO 130
R11.2 n_LED_CAPS_N n_LED_CAPS 130
C3.1 n_p5V 0 47u
C3.2 n_p5V 0 47u
C5.1 n_p5V 0 47n
C5.2 n_p5V 0 47n
C5.3 n_p5V 0 47n
C5.4 n_p5V 0 47n
C5.5 n_p5V 0 47n
L1.1 n_TA_TAKT L1_1_series 1u
RL1.1 L1_1_series n_CABLE_TAKT 1
L1.2 0 L1_2_series 1u
RL1.2 L1_2_series n_CABLE_GND 1
L1.3 n_p5V L1_3_series 1u
RL1.3 L1_3_series n_CABLE_5V 1
L1.4 n_TA_DATEN L1_4_series 1u
RL1.4 L1_4_series n_CABLE_DATEN 1
.model OUTPUT_SINK_NOMINAL SW(RON=20 ROFF=1t VT=2.5 VH=0)
.model LED_NOMINAL D(IS=1e-20 N=2 RS=2)
Sdata n_TA_DATEN 0 data_intent 0 OUTPUT_SINK_NOMINAL
Cdata_load n_CABLE_DATEN n_CABLE_GND 1000p
Rdata_load n_CABLE_DATEN n_CABLE_GND 100k
Sclock n_TA_TAKT 0 clock_intent 0 OUTPUT_SINK_NOMINAL
Cclock_load n_CABLE_TAKT n_CABLE_GND 1000p
Rclock_load n_CABLE_TAKT n_CABLE_GND 100k
Bsiso_target siso_target 0 V=V(n_p5V)*(0.7-0.66*V(siso_intent)/5)
Rsiso_output siso_target n_LED_SISO_N 30
Dsiso_led n_p5V n_LED_SISO LED_NOMINAL
Bcaps_target caps_target 0 V=V(n_p5V)*(0.7-0.66*V(caps_intent)/5)
Rcaps_output caps_target n_LED_CAPS_N 30
Dcaps_led n_p5V n_LED_CAPS LED_NOMINAL
Cbus_A1_3 n_D0 0 4.9999999999999997e-12
Cbus_A4_19 n_D0 0 4.9999999999999997e-12
Cbus_A5_14 n_D0 0 9.9999999999999994e-12
Cbus_A8_9 n_D0 0 1.2000000000000001e-11
Cbus_A4_18 n_D1 0 4.9999999999999997e-12
Cbus_A5_15 n_D1 0 9.9999999999999994e-12
Cbus_A8_10 n_D1 0 1.2000000000000001e-11
Cbus_A4_17 n_D2 0 4.9999999999999997e-12
Cbus_A5_12 n_D2 0 9.9999999999999994e-12
Cbus_A8_11 n_D2 0 1.2000000000000001e-11
Cbus_A4_16 n_D3 0 4.9999999999999997e-12
Cbus_A5_8 n_D3 0 9.9999999999999994e-12
Cbus_A8_13 n_D3 0 1.2000000000000001e-11
Cbus_A4_15 n_D4 0 4.9999999999999997e-12
Cbus_A5_7 n_D4 0 9.9999999999999994e-12
Cbus_A8_14 n_D4 0 1.2000000000000001e-11
Cbus_A4_14 n_D5 0 4.9999999999999997e-12
Cbus_A5_9 n_D5 0 9.9999999999999994e-12
Cbus_A8_15 n_D5 0 1.2000000000000001e-11
Cbus_A4_13 n_D6 0 4.9999999999999997e-12
Cbus_A5_10 n_D6 0 9.9999999999999994e-12
Cbus_A8_16 n_D6 0 1.2000000000000001e-11
Cbus_A4_12 n_D7 0 4.9999999999999997e-12
Cbus_A5_13 n_D7 0 9.9999999999999994e-12
Cbus_A8_17 n_D7 0 1.2000000000000001e-11
Bbus_low_0 n_D0 0 I=V(n_D0)*V(bus_low_0)/(5*222.22222222222223)
Bbus_high_0 n_p5V n_D0 I=(V(n_p5V)-V(n_D0))*V(bus_high_0)/(5*10400)
Bbus_low_1 n_D1 0 I=V(n_D1)*V(bus_low_1)/(5*222.22222222222223)
Bbus_high_1 n_p5V n_D1 I=(V(n_p5V)-V(n_D1))*V(bus_high_1)/(5*10400)
Bbus_low_2 n_D2 0 I=V(n_D2)*V(bus_low_2)/(5*222.22222222222223)
Bbus_high_2 n_p5V n_D2 I=(V(n_p5V)-V(n_D2))*V(bus_high_2)/(5*10400)
Bbus_low_3 n_D3 0 I=V(n_D3)*V(bus_low_3)/(5*222.22222222222223)
Bbus_high_3 n_p5V n_D3 I=(V(n_p5V)-V(n_D3))*V(bus_high_3)/(5*10400)
Bbus_low_4 n_D4 0 I=V(n_D4)*V(bus_low_4)/(5*222.22222222222223)
Bbus_high_4 n_p5V n_D4 I=(V(n_p5V)-V(n_D4))*V(bus_high_4)/(5*10400)
Bbus_low_5 n_D5 0 I=V(n_D5)*V(bus_low_5)/(5*222.22222222222223)
Bbus_high_5 n_p5V n_D5 I=(V(n_p5V)-V(n_D5))*V(bus_high_5)/(5*10400)
Bbus_low_6 n_D6 0 I=V(n_D6)*V(bus_low_6)/(5*222.22222222222223)
Bbus_high_6 n_p5V n_D6 I=(V(n_p5V)-V(n_D6))*V(bus_high_6)/(5*10400)
Bbus_low_7 n_D7 0 I=V(n_D7)*V(bus_low_7)/(5*222.22222222222223)
Bbus_high_7 n_p5V n_D7 I=(V(n_p5V)-V(n_D7))*V(bus_high_7)/(5*10400)
Bbus_low_8 n_D0 0 I=V(n_D0)*V(bus_low_8)/(5*214.28571428571431)
Bbus_high_8 n_p5V n_D0 I=(V(n_p5V)-V(n_D0))*V(bus_high_8)/(5*6500)
Bbus_low_9 n_D1 0 I=V(n_D1)*V(bus_low_9)/(5*214.28571428571431)
Bbus_high_9 n_p5V n_D1 I=(V(n_p5V)-V(n_D1))*V(bus_high_9)/(5*6500)
Bbus_low_10 n_D2 0 I=V(n_D2)*V(bus_low_10)/(5*214.28571428571431)
Bbus_high_10 n_p5V n_D2 I=(V(n_p5V)-V(n_D2))*V(bus_high_10)/(5*6500)
Bbus_low_11 n_D3 0 I=V(n_D3)*V(bus_low_11)/(5*214.28571428571431)
Bbus_high_11 n_p5V n_D3 I=(V(n_p5V)-V(n_D3))*V(bus_high_11)/(5*6500)
Bbus_low_12 n_D4 0 I=V(n_D4)*V(bus_low_12)/(5*214.28571428571431)
Bbus_high_12 n_p5V n_D4 I=(V(n_p5V)-V(n_D4))*V(bus_high_12)/(5*6500)
Bbus_low_13 n_D5 0 I=V(n_D5)*V(bus_low_13)/(5*214.28571428571431)
Bbus_high_13 n_p5V n_D5 I=(V(n_p5V)-V(n_D5))*V(bus_high_13)/(5*6500)
Bbus_low_14 n_D6 0 I=V(n_D6)*V(bus_low_14)/(5*214.28571428571431)
Bbus_high_14 n_p5V n_D6 I=(V(n_p5V)-V(n_D6))*V(bus_high_14)/(5*6500)
Bbus_low_15 n_D7 0 I=V(n_D7)*V(bus_low_15)/(5*214.28571428571431)
Bbus_high_15 n_p5V n_D7 I=(V(n_p5V)-V(n_D7))*V(bus_high_15)/(5*6500)
Bbus_low_16 n_D0 0 I=V(n_D0)*V(bus_low_16)/(5*22.5)
Bbus_high_16 n_p5V n_D0 I=(V(n_p5V)-V(n_D0))*V(bus_high_16)/(5*520)
Bbus_low_17 n_D1 0 I=V(n_D1)*V(bus_low_17)/(5*22.5)
Bbus_high_17 n_p5V n_D1 I=(V(n_p5V)-V(n_D1))*V(bus_high_17)/(5*520)
Bbus_low_18 n_D2 0 I=V(n_D2)*V(bus_low_18)/(5*22.5)
Bbus_high_18 n_p5V n_D2 I=(V(n_p5V)-V(n_D2))*V(bus_high_18)/(5*520)
Bbus_low_19 n_D3 0 I=V(n_D3)*V(bus_low_19)/(5*22.5)
Bbus_high_19 n_p5V n_D3 I=(V(n_p5V)-V(n_D3))*V(bus_high_19)/(5*520)
Bbus_low_20 n_D4 0 I=V(n_D4)*V(bus_low_20)/(5*22.5)
Bbus_high_20 n_p5V n_D4 I=(V(n_p5V)-V(n_D4))*V(bus_high_20)/(5*520)
Bbus_low_21 n_D5 0 I=V(n_D5)*V(bus_low_21)/(5*22.5)
Bbus_high_21 n_p5V n_D5 I=(V(n_p5V)-V(n_D5))*V(bus_high_21)/(5*520)
Bbus_low_22 n_D6 0 I=V(n_D6)*V(bus_low_22)/(5*22.5)
Bbus_high_22 n_p5V n_D6 I=(V(n_p5V)-V(n_D6))*V(bus_high_22)/(5*520)
Bbus_low_23 n_D7 0 I=V(n_D7)*V(bus_low_23)/(5*22.5)
Bbus_high_23 n_p5V n_D7 I=(V(n_p5V)-V(n_D7))*V(bus_high_23)/(5*520)
Rbus_numerical0 n_D0 0 1e12
Rbus_numerical1 n_D1 0 1e12
Rbus_numerical2 n_D2 0 1e12
Rbus_numerical3 n_D3 0 1e12
Rbus_numerical4 n_D4 0 1e12
Rbus_numerical5 n_D5 0 1e12
Rbus_numerical6 n_D6 0 1e12
Rbus_numerical7 n_D7 0 1e12
Vcontact0 contact0 0 0
Vcontact1 contact1 0 0
Vcontact2 contact2 0 0
Vcontact3 contact3 0 0
Vcontact4 contact4 0 0
Vcontact5 contact5 0 0
Vcontact6 contact6 0 0
Vcontact7 contact7 0 0
Vcontact8 contact8 0 0
Vcontact9 contact9 0 0
Vcontact10 contact10 0 0
Vcontact11 contact11 0 0
Vcontact12 contact12 0 0
Vcontact13 contact13 0 0
Vcontact14 contact14 0 0
Vcontact15 contact15 0 0
Vcontact16 contact16 0 0
Vcontact17 contact17 0 0
Vcontact18 contact18 0 0
Vcontact19 contact19 0 0
Vcontact20 contact20 0 0
Vcontact21 contact21 0 0
Vcontact22 contact22 0 0
Vcontact23 contact23 0 0
Vcontact24 contact24 0 0
Vcontact25 contact25 0 0
Vcontact26 contact26 0 0
Vcontact27 contact27 0 0
Vcontact28 contact28 0 0
Vcontact29 contact29 0 0
Vcontact30 contact30 0 0
Vcontact31 contact31 0 0
Vcontact32 contact32 0 0
Vcontact33 contact33 0 0
Vcontact34 contact34 0 0
Vcontact35 contact35 0 0
Vcontact36 contact36 0 0
Vcontact37 contact37 0 0
Vcontact38 contact38 0 0
Vcontact39 contact39 0 0
Vcontact40 contact40 0 0
Vcontact41 contact41 0 0
Vcontact42 contact42 0 0
Vcontact43 contact43 0 0
Vcontact44 contact44 0 0
Vcontact45 contact45 0 0
Vcontact46 contact46 0 0
Vcontact47 contact47 0 0
Vcontact48 contact48 0 0
Vcontact49 contact49 0 0
Vcontact50 contact50 0 0
Vcontact51 contact51 0 0
Vcontact52 contact52 0 0
Vcontact53 contact53 0 0
Vcontact54 contact54 0 0
Vcontact55 contact55 0 0
Vcontact56 contact56 0 0
Vcontact57 contact57 0 0
Vcontact58 contact58 0 0
Vcontact59 contact59 0 0
Vcontact60 contact60 0 0
Vcontact61 contact61 0 PWL(0 0 5000000n 0 5000001n 5)
Vcontact62 contact62 0 0
Vcontact63 contact63 0 0
Vcontact64 contact64 0 0
Vcontact65 contact65 0 0
Vcontact66 contact66 0 0
Vcontact67 contact67 0 0
Vcontact68 contact68 0 0
Vcontact69 contact69 0 0
Vcontact70 contact70 0 0
Vcontact71 contact71 0 0
Vcontact72 contact72 0 0
Vcontact73 contact73 0 0
Vcontact74 contact74 0 0
Vcontact75 contact75 0 0
Vcontact76 contact76 0 0
Vcontact77 contact77 0 0
Vcontact78 contact78 0 0
Vcontact79 contact79 0 0
Vcontact80 contact80 0 0
Vcontact81 contact81 0 0
Vcontact82 contact82 0 0
Vcontact83 contact83 0 0
Vcontact84 contact84 0 0
Vcontact85 contact85 0 0
Vcontact86 contact86 0 0
Vcontact87 contact87 0 0
Vcontact88 contact88 0 0
Vcontact89 contact89 0 0
Vcontact90 contact90 0 0
Vcontact91 contact91 0 0
Vcontact92 contact92 0 0
Vcontact93 contact93 0 0
Vcontact94 contact94 0 0
Vcontact95 contact95 0 0
Vcontact96 contact96 0 0
Vcontact97 contact97 0 0
Vcontact98 contact98 0 0
Vcontact99 contact99 0 0
Vcontact100 contact100 0 0
Vcontact101 contact101 0 0
Vcontact102 contact102 0 0
Vcontact103 contact103 0 0
Esiso_intent siso_intent 0 led0_v 0 1
Ecaps_intent caps_intent 0 led1_v 0 1
Edata receiver_data 0 n_CABLE_DATEN n_CABLE_GND 1
Eclock receiver_clock 0 n_CABLE_TAKT n_CABLE_GND 1
.options minbreak=1f
.tran 25n 1002000n
.save v(bus_low_23) v(bus_low_22) v(bus_low_21) v(bus_low_20) v(bus_low_19) v(bus_low_18) v(bus_low_17) v(bus_low_16) v(bus_low_15) v(bus_low_14) v(bus_low_13) v(bus_low_12) v(bus_low_11) v(bus_low_10) v(bus_low_9) v(bus_low_8) v(bus_low_7) v(bus_low_6) v(bus_low_5) v(bus_low_4) v(bus_low_3) v(bus_low_2) v(bus_low_1) v(bus_low_0) v(bus_high_23) v(bus_high_22) v(bus_high_21) v(bus_high_20) v(bus_high_19) v(bus_high_18) v(bus_high_17) v(bus_high_16) v(bus_high_15) v(bus_high_14) v(bus_high_13) v(bus_high_12) v(bus_high_11) v(bus_high_10) v(bus_high_9) v(bus_high_8) v(bus_high_7) v(bus_high_6) v(bus_high_5) v(bus_high_4) v(bus_high_3) v(bus_high_2) v(bus_high_1) v(bus_high_0) v(data_intent) v(clock_intent) v(led1_v) v(led0_v) v(sink12) v(sink11) v(sink10) v(sink9) v(sink8) v(sink7) v(sink6) v(sink5) v(sink4) v(sink3) v(sink2) v(sink1) v(sink0) v(n_D1) v(n_p5V) v(n_CABLE_5V)
.options reltol=1e-06 vntol=1e-09 abstol=1e-15
Vreplay_bus_low_23 bus_low_23 0 PWL(0 0 0.0010020000000000001 0)
Vreplay_bus_low_22 bus_low_22 0 PWL(0 0 0.0010020000000000001 0)
Vreplay_bus_low_21 bus_low_21 0 PWL(0 0 0.0010020000000000001 0)
Vreplay_bus_low_20 bus_low_20 0 PWL(0 0 0.0010020000000000001 0)
Vreplay_bus_low_19 bus_low_19 0 PWL(0 0 0.0010020000000000001 0)
Vreplay_bus_low_18 bus_low_18 0 PWL(0 0 0.0010020000000000001 0)
Vreplay_bus_low_17 bus_low_17 0 PWL(0 0 0.0010020000000000001 0)
Vreplay_bus_low_16 bus_low_16 0 PWL(0 0 0.0010020000000000001 0)
Vreplay_bus_low_15 bus_low_15 0 PWL(0 0 0.0010020000000000001 0)
Vreplay_bus_low_14 bus_low_14 0 PWL(0 0 0.0010010119999999999 0 0.0010010120073520267 0.036760133782440252 0.00100101202205608 0.11028040026311858 0.0010010120514641866 0.25732093322447525 0.0010010121069304388 0.53465219447892953 0.0010010122178629433 1.0893147169878381 0.0010010124397279525 2.1986397630898575 0.0010010128834579708 4.4172898542096943 0.0010010131804578939 5 0.0010020000000000001 5)
Vreplay_bus_low_13 bus_low_13 0 PWL(0 0 0.0010020000000000001 0)
Vreplay_bus_low_12 bus_low_12 0 PWL(0 0 0.0010010119999999999 0 0.0010010120073520267 0.036760133782440252 0.00100101202205608 0.11028040026311858 0.0010010120514641866 0.25732093322447525 0.0010010121069304388 0.53465219447892953 0.0010010122178629433 1.0893147169878381 0.0010010124397279525 2.1986397630898575 0.0010010128834579708 4.4172898542096943 0.0010010131804578939 5 0.0010020000000000001 5)
Vreplay_bus_low_11 bus_low_11 0 PWL(0 0 0.0010020000000000001 0)
Vreplay_bus_low_10 bus_low_10 0 PWL(0 0 0.0010020000000000001 0)
Vreplay_bus_low_9 bus_low_9 0 PWL(0 0 0.0010020000000000001 0)
Vreplay_bus_low_8 bus_low_8 0 PWL(0 0 0.0010020000000000001 0)
Vreplay_bus_low_7 bus_low_7 0 PWL(0 0 0.0010020000000000001 0)
Vreplay_bus_low_6 bus_low_6 0 PWL(0 0 0.0010020000000000001 0)
Vreplay_bus_low_5 bus_low_5 0 PWL(0 0 0.0010020000000000001 0)
Vreplay_bus_low_4 bus_low_4 0 PWL(0 0 0.0010020000000000001 0)
Vreplay_bus_low_3 bus_low_3 0 PWL(0 0 0.0010020000000000001 0)
Vreplay_bus_low_2 bus_low_2 0 PWL(0 0 0.0010020000000000001 0)
Vreplay_bus_low_1 bus_low_1 0 PWL(0 0 0.0010020000000000001 0)
Vreplay_bus_low_0 bus_low_0 0 PWL(0 0 0.0010020000000000001 0)
Vreplay_bus_high_23 bus_high_23 0 PWL(0 0 0.0010020000000000001 0)
Vreplay_bus_high_22 bus_high_22 0 PWL(0 0 0.0010020000000000001 0)
Vreplay_bus_high_21 bus_high_21 0 PWL(0 0 0.0010020000000000001 0)
Vreplay_bus_high_20 bus_high_20 0 PWL(0 0 0.0010020000000000001 0)
Vreplay_bus_high_19 bus_high_19 0 PWL(0 0 0.0010020000000000001 0)
Vreplay_bus_high_18 bus_high_18 0 PWL(0 0 0.0010020000000000001 0)
Vreplay_bus_high_17 bus_high_17 0 PWL(0 0 0.0010020000000000001 0)
Vreplay_bus_high_16 bus_high_16 0 PWL(0 0 0.0010020000000000001 0)
Vreplay_bus_high_15 bus_high_15 0 PWL(0 0 0.0010010119999999999 0 0.0010010120073520267 0.036760133782440252 0.00100101202205608 0.11028040026311858 0.0010010120514641866 0.25732093322447525 0.0010010121069304388 0.53465219447892953 0.0010010122178629433 1.0893147169878381 0.0010010124397279525 2.1986397630898575 0.0010010128834579708 4.4172898542096943 0.0010010131804578939 5 0.0010020000000000001 5)
Vreplay_bus_high_14 bus_high_14 0 PWL(0 0 0.0010020000000000001 0)
Vreplay_bus_high_13 bus_high_13 0 PWL(0 0 0.0010010119999999999 0 0.0010010120073520267 0.036760133782440252 0.00100101202205608 0.11028040026311858 0.0010010120514641866 0.25732093322447525 0.0010010121069304388 0.53465219447892953 0.0010010122178629433 1.0893147169878381 0.0010010124397279525 2.1986397630898575 0.0010010128834579708 4.4172898542096943 0.0010010131804578939 5 0.0010020000000000001 5)
Vreplay_bus_high_12 bus_high_12 0 PWL(0 0 0.0010020000000000001 0)
Vreplay_bus_high_11 bus_high_11 0 PWL(0 0 0.0010010119999999999 0 0.0010010120073520267 0.036760133782440252 0.00100101202205608 0.11028040026311858 0.0010010120514641866 0.25732093322447525 0.0010010121069304388 0.53465219447892953 0.0010010122178629433 1.0893147169878381 0.0010010124397279525 2.1986397630898575 0.0010010128834579708 4.4172898542096943 0.0010010131804578939 5 0.0010020000000000001 5)
Vreplay_bus_high_10 bus_high_10 0 PWL(0 0 0.0010010119999999999 0 0.0010010120073520267 0.036760133782440252 0.00100101202205608 0.11028040026311858 0.0010010120514641866 0.25732093322447525 0.0010010121069304388 0.53465219447892953 0.0010010122178629433 1.0893147169878381 0.0010010124397279525 2.1986397630898575 0.0010010128834579708 4.4172898542096943 0.0010010131804578939 5 0.0010020000000000001 5)
Vreplay_bus_high_9 bus_high_9 0 PWL(0 0 0.0010010119999999999 0 0.0010010120073520267 0.036760133782440252 0.00100101202205608 0.11028040026311858 0.0010010120514641866 0.25732093322447525 0.0010010121069304388 0.53465219447892953 0.0010010122178629433 1.0893147169878381 0.0010010124397279525 2.1986397630898575 0.0010010128834579708 4.4172898542096943 0.0010010131804578939 5 0.0010020000000000001 5)
Vreplay_bus_high_8 bus_high_8 0 PWL(0 0 0.0010010119999999999 0 0.0010010120073520267 0.036760133782440252 0.00100101202205608 0.11028040026311858 0.0010010120514641866 0.25732093322447525 0.0010010121069304388 0.53465219447892953 0.0010010122178629433 1.0893147169878381 0.0010010124397279525 2.1986397630898575 0.0010010128834579708 4.4172898542096943 0.0010010131804578939 5 0.0010020000000000001 5)
Vreplay_bus_high_7 bus_high_7 0 PWL(0 0 0.0010020000000000001 0)
Vreplay_bus_high_6 bus_high_6 0 PWL(0 0 0.0010020000000000001 0)
Vreplay_bus_high_5 bus_high_5 0 PWL(0 0 0.0010020000000000001 0)
Vreplay_bus_high_4 bus_high_4 0 PWL(0 0 0.0010020000000000001 0)
Vreplay_bus_high_3 bus_high_3 0 PWL(0 0 0.0010020000000000001 0)
Vreplay_bus_high_2 bus_high_2 0 PWL(0 0 0.0010020000000000001 0)
Vreplay_bus_high_1 bus_high_1 0 PWL(0 0 0.0010020000000000001 0)
Vreplay_bus_high_0 bus_high_0 0 PWL(0 0 0.0010020000000000001 0)
Vreplay_data_intent data_intent 0 PWL(0 0 0.0010010694321930015 0 0.0010010694417930015 0.048000000241882335 0.0010010694609930016 0.144000000725647 0.001001069499393002 0.33600000277737851 0.0010010695761930026 0.72000000579663936 0.0010010697297930039 1.4880000118351611 0.0010010697702430033 1.6902500091838664 0.0010010698410305027 2.0441875058993531 0.001001069860623471 2.1421523474333961 0.0010010698949111665 2.3135908249968811 0.0010010699075306774 2.3766883795219025 0.0010010699156271215 2.4171705999623265 0.0010010699259068651 2.4685693181432384 0.0010010699303621973 2.4908459789110138 0.0010010699321618376 2.4998441804004878 0.0010010699331524427 2.5 0.0010011367352906013 2.5 0.0010011375180601332 5 0.0010020000000000001 5)
Vreplay_clock_intent clock_intent 0 PWL(0 0 1e-08 0 1.0206894313323158e-08 1.0344715666157871 1.0264351629575067e-08 1.321758147875332 1.0364901933015904e-08 1.8245096650795189 1.0392732820575423e-08 1.9636641028771136 1.0441436873804577e-08 2.2071843690228854 1.0454917459966219e-08 2.2745872998310928 1.0478508485749094e-08 2.3925424287454677 1.0504627121437273e-08 2.5231356071863638 1.0556864392813631e-08 2.7843219640681562 1.0661338935566348e-08 3.3066946778317412 1.0755515951303998e-08 3.7775797565199896 1.0943869982779299e-08 4.7193499138964947 1.13205780457299e-08 5 0.0010020000000000001 5)
Vreplay_led1_v led1_v 0 PWL(0 0 0.0010020000000000001 0)
Vreplay_led0_v led0_v 0 PWL(0 0 0.0010020000000000001 0)
Vreplay_sink12 sink12 0 PWL(0 0 0.0010020000000000001 0)
Vreplay_sink11 sink11 0 PWL(0 0 0.0010020000000000001 0)
Vreplay_sink10 sink10 0 PWL(0 0 0.0010020000000000001 0)
Vreplay_sink9 sink9 0 PWL(0 0 0.0010020000000000001 0)
Vreplay_sink8 sink8 0 PWL(0 0 0.0010020000000000001 0)
Vreplay_sink7 sink7 0 PWL(0 0 0.0010020000000000001 0)
Vreplay_sink6 sink6 0 PWL(0 0 0.0010020000000000001 0)
Vreplay_sink5 sink5 0 PWL(0 0 0.0010020000000000001 0)
Vreplay_sink4 sink4 0 PWL(0 0 0.0010020000000000001 0)
Vreplay_sink3 sink3 0 PWL(0 0 0.0010020000000000001 0)
Vreplay_sink2 sink2 0 PWL(0 0 0.0010020000000000001 0)
Vreplay_sink1 sink1 0 PWL(0 0 0.0010020000000000001 0)
Vreplay_sink0 sink0 0 PWL(0 0 0.0010020000000000001 0)
Vdiagnostic_rail n_p5V 0 5
.control
set numdgt=17
set wr_singlescale
set wr_vecnames
run
wrdata boundary.txt v(bus_low_23) v(bus_low_22) v(bus_low_21) v(bus_low_20) v(bus_low_19) v(bus_low_18) v(bus_low_17) v(bus_low_16) v(bus_low_15) v(bus_low_14) v(bus_low_13) v(bus_low_12) v(bus_low_11) v(bus_low_10) v(bus_low_9) v(bus_low_8) v(bus_low_7) v(bus_low_6) v(bus_low_5) v(bus_low_4) v(bus_low_3) v(bus_low_2) v(bus_low_1) v(bus_low_0) v(bus_high_23) v(bus_high_22) v(bus_high_21) v(bus_high_20) v(bus_high_19) v(bus_high_18) v(bus_high_17) v(bus_high_16) v(bus_high_15) v(bus_high_14) v(bus_high_13) v(bus_high_12) v(bus_high_11) v(bus_high_10) v(bus_high_9) v(bus_high_8) v(bus_high_7) v(bus_high_6) v(bus_high_5) v(bus_high_4) v(bus_high_3) v(bus_high_2) v(bus_high_1) v(bus_high_0) v(data_intent) v(clock_intent) v(led1_v) v(led0_v) v(sink12) v(sink11) v(sink10) v(sink9) v(sink8) v(sink7) v(sink6) v(sink5) v(sink4) v(sink3) v(sink2) v(sink1) v(sink0) v(n_D1) v(n_p5V) v(n_CABLE_5V)
quit
.endc
.end
