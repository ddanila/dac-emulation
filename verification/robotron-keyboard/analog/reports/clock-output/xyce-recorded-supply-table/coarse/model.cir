* Exploratory LS-TTL output model permitting an external high-level pullup.
* Not transistor-level DL000 calibration. Threshold, pole and resistances remain
* assumptions. Output current comes from vp or returns to g; quiescent package
* current, junction capacitance and temperature behavior are not represented.
.subckt LS_NAND_NOMINAL a b y vp g params: threshold=1.4 width=0.1 pole=5n rout=30 rout_high=50 cin=3p
Btarget target g V={1-(1+tanh((V(a,g)-threshold)/width))*(1+tanh((V(b,g)-threshold)/width))/4}
Rpole target filtered 1k
Cpole filtered g {pole/1000}
* The high-state source cannot sink current from an external pullup.
Bhigh vp y I={max(0,0.7*V(vp,g)-V(y,g))*V(filtered,g)/rout_high}
Blow y g I={V(y,g)*(1-V(filtered,g))/rout}
Roff y g 1t
Ca a g {cin}
Cb b g {cin}
Bia vp a I={max(0,(0.32*V(vp,g)-V(a,g))/10000)}
Bib vp b I={max(0,(0.32*V(vp,g)-V(b,g))/10000)}
Da g a INPUT_CLAMP_NOMINAL
Db g b INPUT_CLAMP_NOMINAL
.model INPUT_CLAMP_NOMINAL D(IS=1e-14 N=1 RS=20)
.ends LS_NAND_NOMINAL
